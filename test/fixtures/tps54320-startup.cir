* TPS54320 startup benchmark: 12 V input, 1.1 ohm load, first 50 us
* TI model: https://www.ti.com/lit/zip/slvm451
* Exported from the Desktop tscircuit circuit without changing electrical values.
.SUBCKT library_simulation_spice_subcircuit_0 BOOT COMP EN ETPad GND_1 GND_2 PH_1 PH_2 PVIN_1 PVIN_2 PWRGD RT_CLK SS_TR VIN VSENSE
*$
* TPS54320
*****************************************************************************
* (C) Copyright 2011 Texas Instruments Incorporated. All rights reserved.
*****************************************************************************
** This model is designed as an aid for customers of Texas Instruments.
** TI and its licensors and suppliers make no warranties, either expressed
** or implied, with respect to this model, including the warranties of
** merchantability or fitness for a particular purpose.  The model is
** provided solely on an "as is" basis.  The entire risk as to its quality
** and performance is with the customer
*****************************************************************************
*
* This model is subject to change without notice. Texas Instruments
* Incorporated is not responsible for updating this model.
*
*****************************************************************************
*
** Released by: Analog eLab Design Center, Texas Instruments Inc.
* Part: TPS54320
* Date: 10NOV2011
* Model Type: TRANSIENT
* Simulator: PSPICE
* Simulator Version: 16.0.0.p001
* EVM Order Number: TPS54320EVM-513
* EVM Users Guide: SLVU380–September 2010
* Datasheet: SLVS982A –AUGUST 2010–REVISED SEPTEMBER 2010
*
* Model Version: Final 1.00
*
*****************************************************************************
*
* Updates:
*
* Final 1.00
* Release to Web.
*
*****************************************************************************
.SUBCKT TPS54320_TRANS BOOT COMP EN ETPad GND_1 GND_2 PH_1 PH_2 PVIN_1
+  PVIN_2 PWRGD RT_CLK SS_TR VIN VSENSE
R_R9         ETPad 0  1m
R_R7         PVIN_2 PVIN  1m
V_V47         SET0 0 0Vdc
V_U1_V64         U1_N16630902 0 3.85
D_U1_D9         EN VIN D_D1
X_U1_U827         U1_N16630902 VIN U1_N16631004 U1_N16632234 COMPHYS_BASIC_GEN
+  PARAMS:  VDD=1 VSS=0 VTHRESH=0.5
D_U1_D8         EN U1_N7335522 D_D1
E_U1_ABM173         U1_N7335522 0 VALUE { {IF(V(U1_N16632234) < 0.5,3,0)}    }
V_U1_V65         U1_N16631004 0 0.15
V_U1_V66         U1_N16636530 0 1.17
X_U1_U828         U1_N16636530 EN U1_N16632710 U1_N16636677 COMPHYS_BASIC_GEN
+  PARAMS:  VDD=1 VSS=0 VTHRESH=0.5
R_U1_R256         EN U1_N7335522  100MEG
X_U1_U619         U1_N16636677 U1_N16636620 INV_BASIC_GEN PARAMS: VDD=1 VSS=0
+  VTHRESH=500E-3
G_U1_ABMII1         VIN EN VALUE { {1.15u+ 3.4u*V(ENAB)}    }
V_U1_V67         U1_N16632710 0 0.04
C_U1_C1         0 ENAB  1n
R_U1_R1         U1_N16636620 ENAB  1
E_U7_ABM13         U7_N16489586 0 VALUE { IF(V(COMP) <0.55 ,1,0)    }
X_U7_U824         U7_N16489522 U7_INDELAYED1 PWM_CLK U7_OR2OUT1 OR3_BASIC_GEN
+  PARAMS: VDD=1 VSS=0 VTHRESH=500E-3
D_U7_D10         U7_N16509288 U7_INDELAYED2 D_D
X_U7_U6         U7_OR2OUT1 U7_OR2OUT2 U7_N16490100 PWM_FINAL MUX2_BASIC_GEN
+  PARAMS: VDD=1 VSS=0 VTHRESH=0.5
X_U7_U822         PWM_CLK U7_N16497188 INV_DELAY_BASIC_GEN PARAMS: VDD=1 VSS=0
+  VTHRESH=0.5 DELAY=15n
C_U7_C172         0 U7_INDELAYED1  10p
R_U7_R273         U7_N16489586 U7_N16490100  1
X_U7_U826         PWM_CLK U7_N16509390 INV_DELAY_BASIC_GEN PARAMS: VDD=1 VSS=0
+  VTHRESH=0.5 DELAY=15n
X_U7_U827         U7_N16509390 PWM_CLK U7_N16509288 AND2_BASIC_GEN PARAMS:
+  VDD=1 VSS=0 VTHRESH=500E-3
R_U7_R272         U7_N16489522 U7_INDELAYED1  13.68k
R_U7_R276         U7_N16509288 U7_INDELAYED2  18k
C_U7_C171         0 U7_N16490100  1n
X_U7_U823         U7_N16497188 PWM_CLK U7_N16489522 AND2_BASIC_GEN PARAMS:
+  VDD=1 VSS=0 VTHRESH=500E-3
C_U7_C177         0 U7_INDELAYED2  10p
X_U7_U825         U7_N16509288 U7_INDELAYED2 PWM_CLK U7_OR2OUT2 OR3_BASIC_GEN
+  PARAMS: VDD=1 VSS=0 VTHRESH=500E-3
D_U7_D9         U7_N16489522 U7_INDELAYED1 D_D
E_U8_ABM152         OCLOW 0 VALUE { {IF(V(U8_N4429050) > 0.5,
+ V(U8_OCLOW_INT),0)}   }
X_U8_U5         U8_N16778977 U8_N16778956 U8_OUT COMP_BASIC_GEN PARAMS: VDD=1
+  VSS=0 VTHRESH=0.5
X_U8_H1    PVIN U8_N16761346 ISW 0 Driver_U8_H1
X_U8_U611         U8_HDRVIN U8_N16774201 BUF_DELAY_BASIC_GEN PARAMS: VDD=1
+  VSS=0 VTHRESH=0.5 DELAY=20n
C_U8_C146         0 U8_N4429050  10p
E_U8_ABM2         U8_N167789271 0 VALUE { ((V(U8_OUT) *-500m)+ 6)    }
X_U8_S35    U8_BOOT_SW_ON 0 BOOT VIN Driver_U8_S35
D_U8_D58         U8_N4429050 U8_N4429086 D_D1
X_U8_S31    LDRV 0 PH U8_N4391901 Driver_U8_S31
R_U8_R3         U8_N167789271 U8_N16778956  1
X_U8_U612         U8_N16774217 U8_N16774225 BUF_DELAY_BASIC_GEN PARAMS: VDD=1
+  VSS=0 VTHRESH=0.5 DELAY=18n
E_U8_ABM151         U8_N4429086 0 VALUE { {IF(V(LDRV) > 0.5, 1,0)}    }
X_U8_S30    HDRV 0 U8_N16761346 PH Driver_U8_S30
R_U8_R249         U8_N16782350 BOOT_UVLO  1
C_U8_C3         0 U8_N16778956  1n
E_U8_ABM171         U8_N16782350 0 VALUE { {IF((V(BOOT) - V(PH)) < 2.1,0,1)}
+  }
X_U8_U602         U8_OUT U8_BOOT_ON INV_BASIC_GEN PARAMS: VDD=1 VSS=0
+  VTHRESH=500E-3
E_U8_ABM169         U8_N16778977 0 VALUE { V(BOOT) - V(PH)    }
C_U8_C142         0 BOOT_UVLO  1n
R_U8_R245         0 BOOT  10MEG
X_U8_H2    U8_N4391901 0 U8_OCLOW_INT 0 Driver_U8_H2
R_U8_R255         U8_N4429086 U8_N4429050  14.4k
D_U8_D13         PH U8_N16761346 D_D1
X_U8_U613         SDWN U8_N16780028 INV_BASIC_GEN PARAMS: VDD=1 VSS=0
+  VTHRESH=500E-3
D_U8_D12         U8_N4391901 PH D_D1
X_U8_U610         U8_HDRVIN U8_N16798848 INV_BASIC_GEN PARAMS: VDD=1 VSS=0
+  VTHRESH=500E-3
X_U8_U615         U8_N16798848 U8_SDWN_N LDRV_MASK U8_N16774217 AND3_BASIC_GEN
+  PARAMS: VDD=1 VSS=0 VTHRESH=500E-3
X_U8_U609         U8_N16774225 U8_N16774217 LDRV AND2_BASIC_GEN PARAMS: VDD=1
+  VSS=0 VTHRESH=500E-3
X_U8_U604         U8_N16780028 PWM_FINAL U8_HDRVIN AND2_BASIC_GEN PARAMS: VDD=1
+  VSS=0 VTHRESH=500E-3
X_U8_U605         U8_HDRVIN U8_N16779393 INV_BASIC_GEN PARAMS: VDD=1 VSS=0
+  VTHRESH=500E-3
X_U8_U608         U8_HDRVIN U8_N16774201 HDRV AND2_BASIC_GEN PARAMS: VDD=1
+  VSS=0 VTHRESH=500E-3
X_U8_U606         SDWN U8_SDWN_N INV_BASIC_GEN PARAMS: VDD=1 VSS=0
+  VTHRESH=500E-3
X_U8_U607         U8_N16779393 ENAB U8_BOOT_ON U8_SDWN_N U8_BOOT_SW_ON
+  AND4_BASIC_GEN PARAMS: VDD=1 VSS=0 VTHRESH=500E-3
R_U11_R287         0 U11_N6045136  1k
X_U11_U604         ENAB U11_N16496294 INV_BASIC_GEN PARAMS: VDD=1 VSS=0
+  VTHRESH=500E-3
V_U11_V64         U11_N6045018 0 3.85
V_U11_V65         U11_N16630658 0 0.15
X_U11_U827         U11_N6045018 VIN U11_N16630658 U11_N6045102
+  COMPHYS_BASIC_GEN PARAMS:  VDD=1 VSS=0 VTHRESH=0.5
C_U11_C163         U11_N6045130 U11_N6045136  140.5p
X_U11_U136         U11_N16496294 U11_N6045102 SDWN OR2_BASIC_GEN PARAMS: VDD=1
+  VSS=0 VTHRESH=500E-3
E_U11_ABM173         SS_DISCH 0 VALUE { {IF(V(SS_TR)  < 54m,0,
+ IF(V(U11_N6045136) > 0.5,1,0))}   }
X_U11_U603         SDWN U11_N6045130 INV_BASIC_GEN PARAMS: VDD=1 VSS=0
+  VTHRESH=500E-3
R_R2         PH PH_1  1m
X_U3_U136         SDWN SYSCLK U3_N16533268 OR2_BASIC_GEN PARAMS: VDD=1 VSS=0
+  VTHRESH=500E-3
C_U3_C80         U3_N16532961 0  4.146p
X_U3_U131         U3_RAMP U3_N16505459 SYSCLK COMP_BASIC_GEN PARAMS: VDD=1
+  VSS=0 VTHRESH=0.5
I_U3_I1 0 RT_CLK DC 1
E_U3_ABM4         ISLOPE 0 VALUE { MAX(V(U3_N16532961)-0.4,0)*1.875u    }
X_U3_U135         SYSCLK U3_N16517387 BUF_DELAY_BASIC_GEN PARAMS: VDD=1 VSS=0
+  VTHRESH=0.5 DELAY=20n
V_U3_V45         U3_N16490106 0 5
C_U3_C79         U3_RAMP 0  4.146p
D_U3_D11         U3_RAMP U3_N16490106 D_D1
G_U3_ABMII1         U3_N16490106 U3_RAMP VALUE {
+  2*4.146p*(75.8893G/V(RT_CLK))**0.968    }
X_U3_S26    U3_N16655199 0 U3_RAMP 0 Oscillator_U3_S26
X_U3_S27    U3_N16533268 0 U3_N16532961 0 Oscillator_U3_S27
D_U3_D12         U3_N16532961 U3_N16490106 D_D1
X_U3_U134         SDWN U3_N16517387 U3_N16655199 OR2_BASIC_GEN PARAMS: VDD=1
+  VSS=0 VTHRESH=500E-3
G_U3_ABMII2         U3_N16490106 U3_N16532961 VALUE {
+  2*4.146p*(75.8893G/V(RT_CLK))**0.968    }
V_U3_V46         U3_N16505459 0 2
R_U9_R284         U9_N7105183 U9_N7105126  14k
C_U9_C5         0 U9_N16552512  1n
C_U9_C7         0 U9_N16553633  1n
R_U9_R7         U9_N165589131 U9_N16553633  1
C_U9_C160         0 U9_N7105126  2n
X_U9_U7         U9_N16553633 VSENSE U9_OVP COMP_BASIC_GEN PARAMS: VDD=1 VSS=0
+  VTHRESH=0.5
R_U9_R5         U9_N165587411 U9_N16552512  1
E_U9_ABM5         U9_N165589131 0 VALUE { ((V(U9_OVP)*24m) + 0.848)    }
X_U9_U612         U9_UVP U9_OVP U9_N16557840 U9_N7105183 NAND3_BASIC_GEN
+  PARAMS: VDD=1 VSS=0 VTHRESH=500E-3
X_U9_U6         VSENSE U9_N16552512 U9_UVP COMP_BASIC_GEN PARAMS: VDD=1 VSS=0
+  VTHRESH=0.5
X_U9_U611         SDWN U9_N16557840 INV_BASIC_GEN PARAMS: VDD=1 VSS=0
+  VTHRESH=500E-3
X_U9_U613         U9_N7105126 U9_N16562732 BUF_BASIC_GEN PARAMS: VDD=1 VSS=0
+  VTHRESH=0.5
E_U9_ABM4         U9_N165587411 0 VALUE { ((V(U9_UVP)*-24m) + 0.752)    }
X_U9_S19    U9_N16562732 0 PWRGD 0 PGOOD_U9_S19
R_R3         PH PH_2  1m
C_U4_C8         0 SS_TR  0.1p
C_U4_C14         0 VREF_GM  1n
D_U4_D62         SS_TR U4_N7397984 D_D1
X_U4_U1         SDWN U4_N16637245 INV_BASIC_GEN PARAMS: VDD=1 VSS=0
+  VTHRESH=500E-3
X_U4_U827         HICCUP_N U4_N16637245 U4_N16572832 AND2_BASIC_GEN PARAMS:
+  VDD=1 VSS=0 VTHRESH=500E-3
D_U4_D63         0 SS_TR D_D1
V_U4_V70         U4_N7397984 0 1.7
C_U4_C15         0 U4_N7398492  100n
G_U4_ABMI5         SS_TR 0 VALUE { {IF(V(SS_DISCH) > 2.5, 1.25e-3,0)}    }
X_U4_S68    U4_N7398492 0 SS_TR U4_N7406021 SoftStart_U4_S68
X_U4_U2         HICCUP_N U4_N16637584 INV_BASIC_GEN PARAMS: VDD=1 VSS=0
+  VTHRESH=500E-3
E_U4_ABM178         U4_N16569567 0 VALUE { IF(V(SS_TR) < 0.8, V(SS_TR),0.8)
+  }
G_U4_ABMII1         U4_N7397984 SS_TR VALUE { {IF(V(U4_N16572832) >
+  0.5,2.3u,0)}    }
V_U4_V72         U4_N7406021 0 -0.1mVdc
R_U4_R15         U4_N16639089 U4_N7398492  1
X_U4_U825         SDWN OCB U4_N16637584 U4_N16639089 OR3_BASIC_GEN PARAMS:
+  VDD=1 VSS=0 VTHRESH=500E-3
R_U4_R14         U4_N16569567 VREF_GM  1
V_U5_V5         U5_N7407325 0 0.25
C_U5_C11         0 OCB  1n
G_U5_ABM2I3         0 U5_N7406901 VALUE { {V(VREF_GM) - V(VSENSE)}    }
C_U5_C5         0 COMP  20.64p
G_U5_ABM2I1         0 COMP VALUE { {LIMIT((V(U5_N7406901) - V(0))*1300u,
+  -110u,110u)}    }
R_U5_R7         0 U5_N7406901  1
C_U5_C10         0 U5_N7406901  79.6n
V_U5_V6         U5_N7407271 0 1.5
R_U5_R4         0 COMP  2.384MEG
D_U5_D10         COMP U5_N7407271 D_D
R_U5_R12         U5_N7406885 OCB  1
E_U5_ABM8         U5_N7406885 0 VALUE { {IF(V(COMP) > 1.5,5,0)}    }
D_U5_D9         U5_N7407325 COMP D_D
R_R4         GND_1 GND  1m
V_V46         SET1 0 1
R_R5         GND 0  1m
X_U6_U608         N16559015 U6_N16559133 U6_N16560525 SET1 U6_N16558784
+  U6_SDWN_N DFFSBRB_RHPBASIC_GEN PARAMS: VDD=1 VSS=0 VTHRESH=500E-3
E_U6_ABM164         U6_ICTRL 0 VALUE { (((V(COMP)
+  -0.25)/83.34k)-V(ISLOPE))*1MEG    }
X_U6_U601         U6_N16489001 VSENSE U6_OVTP COMP_BASIC_GEN PARAMS: VDD=1
+  VSS=0 VTHRESH=0.5
V_U6_V84         U6_N16582213 0 0.25
X_U6_U603         PWM_CLK N16528816 SYSCLK SET1 U6_N16580873 SET1
+  DFFSBRB_RHPBASIC_GEN PARAMS: VDD=1 VSS=0 VTHRESH=500E-3
X_U6_U612         LDRV U6_N16562380 INV_BASIC_GEN PARAMS: VDD=1 VSS=0
+  VTHRESH=500E-3
E_U6_ABM152         U6_ISWF 0 VALUE { {IF(V(U6_N16489275) > 0.5,
+ V(ISW),0.0)}   }
X_U6_U615         N16566065 U6_N16566204 U6_LSTO SET1 U6_N16566345 SET1
+  DFFSBRB_RHPBASIC_GEN PARAMS: VDD=1 VSS=0 VTHRESH=500E-3
X_U6_U606         COMP U6_N16582213 U6_N16580393 COMP_BASIC_GEN PARAMS: VDD=1
+  VSS=0 VTHRESH=0.5
X_U6_U617         U6_N16569604 OCLOW U6_LSTI COMP_BASIC_GEN PARAMS: VDD=1 VSS=0
+  VTHRESH=0.5
X_U6_S2    U6_N16781913 0 U6_LSTO 0 GmIphase_U6_S2
V_U6_V79         U6_N16489001 0 0.872
X_U6_U605         U6_N16522994 BOOT_UVLO U6_OVTP U6_CBC_ILIMT U6_N16577763
+  AND4_BASIC_GEN PARAMS: VDD=1 VSS=0 VTHRESH=500E-3
X_U6_U620         U6_N16577763 U6_VALLEY_ILIMIT U6_N16580393 HICCUP_N
+  U6_N16580873 AND4_BASIC_GEN PARAMS: VDD=1 VSS=0 VTHRESH=500E-3
X_U6_U1_U609         U6_U1_N16584252 U6_U1_N16592940 U6_U1_HICCUP
+  U6_U1_N16584335 SRLATCHRHP_BASIC_GEN PARAMS: VDD=1 VSS=0 VTHRESH=0.5
X_U6_U1_U822         U6_U1_N16571189 U6_U1_N16574796 INV_DELAY_BASIC_GEN
+  PARAMS: VDD=1 VSS=0 VTHRESH=0.5 DELAY=10u
R_U6_U1_R5         0 U6_U1_N16599613  100M
V_U6_U1_V1         U6_U1_N16572166 0 520
X_U6_U1_U620         U6_U1_N16584335 U6_U1_N16580488 SYSCLK U6_U1_N16580344
+  AND3_BASIC_GEN PARAMS: VDD=1 VSS=0 VTHRESH=500E-3
C_U6_U1_C4         0 U6_U1_HICCUP_SD  500n
C_U6_U1_U1_C1         0 U6_U1_U1_YA  1n
E_U6_U1_U1_E4         U6_U1_U1_N33534 0 VALUE { IF(V(U6_U1_COMP_NORMAL)>0.5, 0,
+  1) }
R_U6_U1_U1_R6         0 U6_U1_N00913  100G
V_U6_U1_U1_V1         U6_U1_U1_VSUP 0 1Vdc
C_U6_U1_U1_C3         0 U6_U1_N00913  1p
G_U6_U1_U1_ABM2I2         U6_U1_U1_YA 0 VALUE { IF(V(U6_U1_N00872)<0.5,0,
+  V(U6_U1_U1_YA)/1m)    }
E_U6_U1_U1_E3         U6_U1_U1_N32221 0 VALUE {
+  IF((V(U6_U1_U1_P)>0.5)&(V(U6_U1_U1_YTD)>0.5), 1, 0) }
R_U6_U1_U1_R7         U6_U1_U1_N33534 U6_U1_N00913  1m
E_U6_U1_U1_E2         U6_U1_U1_P 0 VALUE { IF((~(V(U6_U1_U1_YTD) >
+  0.5)&(V(U6_U1_N00872) > .5))|((V(U6_U1_U1_YTD) > 0.5)&(~(V(U6_U1_N00872)>
+  .5))), 1, 0) }
R_U6_U1_U1_R4         0 U6_U1_COMP_NORMAL  100G
C_U6_U1_U1_C2         0 U6_U1_COMP_NORMAL  1p
R_U6_U1_U1_R3         0 U6_U1_U1_P  100G
R_U6_U1_U1_R2         0 U6_U1_U1_YTD  100G
R_U6_U1_U1_R5         U6_U1_U1_N32221 U6_U1_COMP_NORMAL  1m
G_U6_U1_U1_ABM2I1         U6_U1_U1_VSUP U6_U1_U1_YA VALUE {
+  IF(V(U6_U1_N00872)<0.5, V(U6_U1_U1_VSUP)/1000K, 0)    }
R_U6_U1_U1_R1         0 U6_U1_U1_YA  100G
E_U6_U1_U1_E1         U6_U1_U1_YTD 0 VALUE { IF(V(U6_U1_U1_YA)> ({PW}*1000), 0,
+  1) }
X_U6_U1_U619         U6_U1_N16594599 U6_U1_N16594683 U6_U1_H_END AND2_BASIC_GEN
+  PARAMS: VDD=1 VSS=0 VTHRESH=500E-3
X_U6_U1_U618         U6_U1_N16571189 U6_U1_N16574796 U6_U1_N16571005
+  AND2_BASIC_GEN PARAMS: VDD=1 VSS=0 VTHRESH=500E-3
X_U6_U1_U826         U6_U1_H_END 0 U6_U1_HICCUP_SD 0 hiccup_u10_s2 PARAMS:
R_U6_U1_R2         U6_U1_N16582477 0  100M
X_U6_U1_U825         U6_U1_N16625840 0 U6_U1_HICCUP_WAIT 0 hiccup_u10_s2
+  PARAMS:
E_U6_U1_E2         U6_U1_N16580488 0 VALUE { IF(V(COMP) > 1.45,1,0) }
E_U6_U1_E1         U6_U1_N00872 0 VALUE { IF(V(COMP) > 1,1,0) }
X_U6_U1_U136         SDWN U6_U1_H_END U6_U1_N16592940 OR2_BASIC_GEN PARAMS:
+  VDD=1 VSS=0 VTHRESH=500E-3
C_U6_U1_C3         0 U6_U1_N16594599  1n
V_U6_U1_V4         U6_U1_N16595597 0 16384.5Vdc
X_U6_U1_U614         U6_U1_HICCUP HICCUP_N INV_BASIC_GEN PARAMS: VDD=1 VSS=0
+  VTHRESH=500E-3
V_U6_U1_V2         U6_U1_N16573481 0 512.5Vdc
R_U6_U1_R4         U6_U1_N16645111 U6_U1_N16594599  1
C_U6_U1_C2         0 U6_U1_HICCUP_WAIT  500n
X_U6_U1_U823         U6_U1_N16594599 U6_U1_N16594683 INV_DELAY_BASIC_GEN
+  PARAMS: VDD=1 VSS=0 VTHRESH=0.5 DELAY=10u
C_U6_U1_C1         0 U6_U1_N16571189  1n
X_U6_U1_U827         U6_U1_HICCUP_SD U6_U1_N16595597 U6_U1_N16635869
+  U6_U1_N16645111 COMPHYS_BASIC_GEN PARAMS:  VDD=1 VSS=0 VTHRESH=0.5
D_U6_U1_D58         U6_U1_HICCUP_WAIT U6_U1_N16572166 D_D1
C_U6_U1_U2_C1         0 U6_U1_U2_YA  1n
E_U6_U1_U2_E4         U6_U1_U2_N33534 0 VALUE { IF(V(U6_U1_N16575610)>0.5, 0,
+  1) }
R_U6_U1_U2_R6         0 U6_U1_N16582477  100G
V_U6_U1_U2_V1         U6_U1_U2_VSUP 0 1Vdc
C_U6_U1_U2_C3         0 U6_U1_N16582477  1p
G_U6_U1_U2_ABM2I2         U6_U1_U2_YA 0 VALUE { IF(V(U6_U1_N16580344)<0.5,0,
+  V(U6_U1_U2_YA)/1m)    }
E_U6_U1_U2_E3         U6_U1_U2_N32221 0 VALUE {
+  IF((V(U6_U1_U2_P)>0.5)&(V(U6_U1_U2_YTD)>0.5), 1, 0) }
R_U6_U1_U2_R7         U6_U1_U2_N33534 U6_U1_N16582477  1m
E_U6_U1_U2_E2         U6_U1_U2_P 0 VALUE { IF((~(V(U6_U1_U2_YTD) >
+  0.5)&(V(U6_U1_N16580344) > .5))|((V(U6_U1_U2_YTD) >
+  0.5)&(~(V(U6_U1_N16580344)> .5))), 1, 0) }
R_U6_U1_U2_R4         0 U6_U1_N16575610  100G
C_U6_U1_U2_C2         0 U6_U1_N16575610  1p
R_U6_U1_U2_R3         0 U6_U1_U2_P  100G
R_U6_U1_U2_R2         0 U6_U1_U2_YTD  100G
R_U6_U1_U2_R5         U6_U1_U2_N32221 U6_U1_N16575610  1m
G_U6_U1_U2_ABM2I1         U6_U1_U2_VSUP U6_U1_U2_YA VALUE {
+  IF(V(U6_U1_N16580344)<0.5, V(U6_U1_U2_VSUP)/1000K, 0)    }
R_U6_U1_U2_R1         0 U6_U1_U2_YA  100G
E_U6_U1_U2_E1         U6_U1_U2_YTD 0 VALUE { IF(V(U6_U1_U2_YA)> ({PW}*1000), 0,
+  1) }
D_U6_U1_D59         U6_U1_HICCUP_SD U6_U1_N16595459 D_D1
X_U6_U1_U617         U6_U1_HICCUP_WAIT U6_U1_N16573481 U6_U1_N16584252
+  COMP_BASIC_GEN PARAMS: VDD=1 VSS=0 VTHRESH=0.5
C_U6_U1_U4_C1         0 U6_U1_U4_YA  1n
E_U6_U1_U4_E4         U6_U1_U4_N33534 0 VALUE { IF(V(U6_U1_RESTART)>0.5, 0, 1)
+  }
R_U6_U1_U4_R6         0 U6_U1_N16599613  100G
V_U6_U1_U4_V1         U6_U1_U4_VSUP 0 1Vdc
C_U6_U1_U4_C3         0 U6_U1_N16599613  1p
G_U6_U1_U4_ABM2I2         U6_U1_U4_YA 0 VALUE { IF(V(U6_U1_N16598914)<0.5,0,
+  V(U6_U1_U4_YA)/1m)    }
E_U6_U1_U4_E3         U6_U1_U4_N32221 0 VALUE {
+  IF((V(U6_U1_U4_P)>0.5)&(V(U6_U1_U4_YTD)>0.5), 1, 0) }
R_U6_U1_U4_R7         U6_U1_U4_N33534 U6_U1_N16599613  1m
E_U6_U1_U4_E2         U6_U1_U4_P 0 VALUE { IF((~(V(U6_U1_U4_YTD) >
+  0.5)&(V(U6_U1_N16598914) > .5))|((V(U6_U1_U4_YTD) >
+  0.5)&(~(V(U6_U1_N16598914)> .5))), 1, 0) }
R_U6_U1_U4_R4         0 U6_U1_RESTART  100G
C_U6_U1_U4_C2         0 U6_U1_RESTART  1p
R_U6_U1_U4_R3         0 U6_U1_U4_P  100G
R_U6_U1_U4_R2         0 U6_U1_U4_YTD  100G
R_U6_U1_U4_R5         U6_U1_U4_N32221 U6_U1_RESTART  1m
G_U6_U1_U4_ABM2I1         U6_U1_U4_VSUP U6_U1_U4_YA VALUE {
+  IF(V(U6_U1_N16598914)<0.5, V(U6_U1_U4_VSUP)/1000K, 0)    }
R_U6_U1_U4_R1         0 U6_U1_U4_YA  100G
E_U6_U1_U4_E1         U6_U1_U4_YTD 0 VALUE { IF(V(U6_U1_U4_YA)> ({PW}*1000), 0,
+  1) }
R_U6_U1_R1         0 U6_U1_N00913  100M
X_U6_U1_U622         U6_U1_HICCUP SYSCLK U6_U1_N16598914 AND2_BASIC_GEN PARAMS:
+  VDD=1 VSS=0 VTHRESH=500E-3
V_U6_U1_V3         U6_U1_N16595459 0 16400
G_U6_U1_G1         0 U6_U1_HICCUP_WAIT U6_U1_N16575610 0 1
X_U6_U1_U134         U6_U1_COMP_NORMAL U6_U1_N16571005 U6_U1_N16625840
+  OR2_BASIC_GEN PARAMS: VDD=1 VSS=0 VTHRESH=500E-3
G_U6_U1_G2         0 U6_U1_HICCUP_SD U6_U1_RESTART 0 1
V_U6_U1_Vhys         U6_U1_N16635869 0 16384.49Vdc
R_U6_U1_R3         U6_U1_HICCUP U6_U1_N16571189  1
R_U6_R255         U6_N16489395 U6_N16489275  14.4k
X_U6_U607         U6_N16554924 OCLOW U6_VALLEY_ILIMIT COMP_BASIC_GEN PARAMS:
+  VDD=1 VSS=0 VTHRESH=0.5
R_U6_R256         U6_LSTI U6_LSTO  28.86
X_U6_U613         U6_N16562380 U6_PBIAS U6_N16560525 AND2_BASIC_GEN PARAMS:
+  VDD=1 VSS=0 VTHRESH=500E-3
C_U6_C146         0 U6_N16489275  5p
C_U6_C147         0 U6_LSTO  1n
V_U6_V80         U6_N16552171 0 6.2
D_U6_D58         U6_N16489275 U6_N16489395 D_D1
X_U6_U610         SS_TR VSENSE U6_N16556945 COMP_BASIC_GEN PARAMS: VDD=1 VSS=0
+  VTHRESH=0.5
V_U6_V81         U6_N16554924 0 5.8
X_U6_S1    U6_SYSCLK_N 0 U6_LSTI U6_LSTO GmIphase_U6_S1
X_U6_U618         U6_N16566204 U6_N16559133 LDRV_MASK AND2_BASIC_GEN PARAMS:
+  VDD=1 VSS=0 VTHRESH=500E-3
X_U6_U600         U6_ICTRL U6_ISWF U6_N16522994 COMP_BASIC_GEN PARAMS: VDD=1
+  VSS=0 VTHRESH=0.5
X_U6_U609         SDWN U6_N16556945 U6_PBIAS N16557147 SRLATCHRHP_BASIC_GEN
+  PARAMS: VDD=1 VSS=0 VTHRESH=0.5
X_U6_U621         U6_LSTO U6_N16781913 BUF_DELAY_BASIC_GEN PARAMS: VDD=1 VSS=0
+  VTHRESH=0.5 DELAY=30n
X_U6_U616         U6_SYSCLK_N U6_SDWN_N U6_N16566345 AND2_BASIC_GEN PARAMS:
+  VDD=1 VSS=0 VTHRESH=500E-3
X_U6_U611         HDRV U6_N16558784 INV_BASIC_GEN PARAMS: VDD=1 VSS=0
+  VTHRESH=500E-3
V_U6_V83         U6_N16569604 0 -2.6
X_U6_U604         U6_N16552171 ISW U6_CBC_ILIMT COMP_BASIC_GEN PARAMS: VDD=1
+  VSS=0 VTHRESH=0.5
E_U6_ABM151         U6_N16489395 0 VALUE { {IF(V(HDRV) > 0.5, 1,0)}    }
X_U6_U619         SYSCLK U6_SYSCLK_N INV_BASIC_GEN PARAMS: VDD=1 VSS=0
+  VTHRESH=500E-3
X_U6_U614         SDWN U6_SDWN_N INV_BASIC_GEN PARAMS: VDD=1 VSS=0
+  VTHRESH=500E-3
R_R8         GND_2 GND  1m
R_R6         PVIN_1 PVIN  1m
.IC         V(SS_TR)=0
.ENDS TPS54320_TRANS

.PARAM  pw=500n

.subckt Driver_U8_H1 1 2 3 4
H_U8_H1         3 4 VH_U8_H1 1
VH_U8_H1         1 2 0V
.ends Driver_U8_H1

.subckt Driver_U8_S35 1 2 3 4
S_U8_S35         3 4 1 2 _U8_S35
RS_U8_S35         1 2 1G
.MODEL         _U8_S35 VSWITCH Roff=10e6 Ron=15 Voff=0.2 Von=0.8
.ends Driver_U8_S35

.subckt Driver_U8_S31 1 2 3 4
S_U8_S31         3 4 1 2 _U8_S31
RS_U8_S31         1 2 1G
.MODEL         _U8_S31 VSWITCH Roff=10e6 Ron=50m Voff=0.2 Von=0.8
.ends Driver_U8_S31

.subckt Driver_U8_S30 1 2 3 4
S_U8_S30         3 4 1 2 _U8_S30
RS_U8_S30         1 2 1G
.MODEL         _U8_S30 VSWITCH Roff=10e6 Ron=77m Voff=0.2 Von=0.8
.ends Driver_U8_S30

.subckt Driver_U8_H2 1 2 3 4
H_U8_H2         3 4 VH_U8_H2 -1
VH_U8_H2         1 2 0V
.ends Driver_U8_H2

.subckt Oscillator_U3_S26 1 2 3 4
S_U3_S26         3 4 1 2 _U3_S26
RS_U3_S26         1 2 1G
.MODEL         _U3_S26 VSWITCH Roff=10e6 Ron=1.0 Voff=0.2 Von=0.8
.ends Oscillator_U3_S26

.subckt Oscillator_U3_S27 1 2 3 4
S_U3_S27         3 4 1 2 _U3_S27
RS_U3_S27         1 2 1G
.MODEL         _U3_S27 VSWITCH Roff=10e6 Ron=1.0 Voff=0.2 Von=0.8
.ends Oscillator_U3_S27

.subckt PGOOD_U9_S19 1 2 3 4
S_U9_S19         3 4 1 2 _U9_S19
RS_U9_S19         1 2 1G
.MODEL         _U9_S19 VSWITCH Roff=100e6 Ron=50 Voff=0.2 Von=0.8
.ends PGOOD_U9_S19

.subckt SoftStart_U4_S68 1 2 3 4
S_U4_S68         3 4 1 2 _U4_S68
RS_U4_S68         1 2 1G
.MODEL         _U4_S68 VSWITCH Roff=100e6 Ron=3571 Voff=0.2 Von=0.8
.ends SoftStart_U4_S68

.subckt GmIphase_U6_S2 1 2 3 4
S_U6_S2         3 4 1 2 _U6_S2
RS_U6_S2         1 2 1G
.MODEL         _U6_S2 VSWITCH Roff=1e6 Ron=1.0 Voff=0.2V Von=0.8V
.ends GmIphase_U6_S2

.subckt GmIphase_U6_S1 1 2 3 4
S_U6_S1         3 4 1 2 _U6_S1
RS_U6_S1         1 2 1G
.MODEL         _U6_S1 VSWITCH Roff=1e6 Ron=1.0 Voff=0.2V Von=0.8V
.ends GmIphase_U6_S1

** Wrapper definitions for AA legacy support **

.model D_D1 d

+ is=1e-015
+ tt=1e-011
+ rs=0.05
+ n=0.1

.model D_D d

+ is=1e-015
+ n=0.01
+ tt=1e-011

.subckt hiccup_u10_s2 1 2 3 4

*.PARAM
s_u10_s2         3 4 1 2 _u10_s2
rs_u10_s2         1 2 1g

.model _u10_s2 vswitch
+ roff=1e+006
+ ron=1
+ voff=0.25
+ von=0.75

.ends hiccup_u10_s2

*$
.SUBCKT OR3_BASIC_GEN A B C Y PARAMS: VDD=1 VSS=0 VTHRESH=0.5
E_ABMGATE    YINT 0 VALUE {{IF(V(A) > {VTHRESH}  |
+ V(B) > {VTHRESH} |
+ V(C) > {VTHRESH},{VDD},{VSS})}}
RINT YINT Y 1
CINT Y 0 1n
.ENDS OR3_BASIC_GEN

*$
.SUBCKT MUX2_BASIC_GEN A B S Y PARAMS: VDD=1 VSS=0 VTHRESH=0.5
E_ABMGATE  YINT 0 VALUE {{IF(V(S) > {VTHRESH},
+ V(B),V(A))}}
RINT YINT Y 1
CINT Y 0 1n
.ENDS MUX2_BASIC_GEN

.SUBCKT INV_DELAY_BASIC_GEN A  Y PARAMS: VDD=1 VSS=0 VTHRESH=0.5 DELAY = 10n
E_ABMGATE1    YINT1 0 VALUE {{IF(V(A) > {VTHRESH} ,
+ {VDD},{VSS})}}
RINT YINT1 YINT2 1
CINT YINT2 0 {DELAY*1.3}
E_ABMGATE2    YINT3 0 VALUE {{IF(V(YINT2) > {VTHRESH} ,
+ {VSS},{VDD})}}
RINT2 YINT3 Y 1
CINT2 Y 0 1n
.ENDS INV_DELAY_BASIC_GEN
*$

.SUBCKT AND2_BASIC_GEN A B Y PARAMS: VDD=1 VSS=0 VTHRESH=0.5
E_ABMGATE    YINT 0 VALUE {{IF(V(A) > {VTHRESH}  &
+ V(B) > {VTHRESH},{VDD},{VSS})}}
RINT YINT Y 1
CINT Y 0 1n
.ENDS AND2_BASIC_GEN
*$

.SUBCKT INV_BASIC_GEN A  Y PARAMS: VDD=1 VSS=0 VTHRESH=0.5
E_ABMGATE    YINT 0 VALUE {{IF(V(A) > {VTHRESH} ,
+ {VSS},{VDD})}}
RINT YINT Y 1
CINT Y 0 1n
.ENDS INV_BASIC_GEN
*$

.SUBCKT AND3_BASIC_GEN A B C Y PARAMS: VDD=1 VSS=0 VTHRESH=0.5
E_ABMGATE    YINT 0 VALUE {{IF(V(A) > {VTHRESH}  &
+ V(B) > {VTHRESH} &
+ V(C) > {VTHRESH},{VDD},{VSS})}}
RINT YINT Y 1
CINT Y 0 1n
.ENDS AND3_BASIC_GEN
*$

.SUBCKT AND4_BASIC_GEN A B C D Y PARAMS: VDD=1 VSS=0 VTHRESH=0.5
E_ABMGATE    YINT 0 VALUE {{IF(V(A) > {VTHRESH}  &
+ V(B) > {VTHRESH} &
+ V(C) > {VTHRESH} &
+ V(D) > {VTHRESH},{VDD},{VSS})}}
RINT YINT Y 1
CINT Y 0 1n
.ENDS AND4_BASIC_GEN
*$

.SUBCKT OR2_BASIC_GEN A B Y PARAMS: VDD=1 VSS=0 VTHRESH=0.5
E_ABMGATE    YINT 0 VALUE {{IF(V(A) > {VTHRESH}  |
+ V(B) > {VTHRESH},{VDD},{VSS})}}
RINT YINT Y 1
CINT Y 0 1n
.ENDS OR2_BASIC_GEN
*$

.SUBCKT NAND3_BASIC_GEN A B C Y PARAMS: VDD=1 VSS=0 VTHRESH=0.5
E_ABMGATE    YINT 0 VALUE {{IF(V(A) > {VTHRESH}  &
+ V(B) > {VTHRESH} &
+ V(C) > {VTHRESH},{VSS},{VDD})}}
RINT YINT Y 1
CINT Y 0 1n
.ENDS NAND3_BASIC_GEN
*$

.SUBCKT DFFSBRB_RHPBASIC_GEN Q QB CLK D RB SB PARAMS: VDD=1 VSS=0 VTHRESH=0.5
***Set has higher priority in this
** Changed the delay from 7n/10n to 15n/20n to help larger time step simulations
**Faster flip-flops require a a smaller time step to simulate
X1 CLK CLKdel INV_DELAY_BASIC_GEN PARAMS: VDD={VDD} VSS={VSS} VTHRESH={VTHRESH} DELAY = 15n
X2 CLK CLKdel CLKint AND2_BASIC_GEN PARAMS: VDD={VDD} VSS={VSS} VTHRESH={VTHRESH}
GQ 0 Qint VALUE = {IF(V(RB) < {VTHRESH},-5,IF(V(SB)< {VTHRESH},5, IF(V(CLKint)> {VTHRESH},
+ IF(V(D)> {VTHRESH},5,-5),0)))}
CQint Qint 0 1n
RQint Qint 0 1000MEG
D_D10 Qint MY5 D_D1
V1 MY5 0 5
D_D11 0 Qint D_D1
EQ Qqq 0 Qint 0 1
X3 Qqq Qqqd1 BUF_DELAY_BASIC_GEN PARAMS: VDD={VDD} VSS={VSS} VTHRESH={VTHRESH} DELAY = 20n
RQq Qqqd1 Q 1
EQb Qbr 0 VALUE = {IF( V(Q) > {VTHRESH}, {VSS},{VDD})}
RQb Qbr Qb 1
Cdummy1 Q 0 1nF
Cdummy2 QB 0 1nF
.IC V(Qint) {VSS}
.ENDS DFFSBRB_RHPBASIC_GEN
*$

**Reset has higher priority in this latch
.SUBCKT SRLATCHRHP_BASIC_GEN S R Q QB PARAMS: VDD=1 VSS=0 VTHRESH=0.5
GQ 0 Qint VALUE = {IF(V(R) > {VTHRESH},-5,IF(V(S)>{VTHRESH},5, 0))}
CQint Qint 0 1n
RQint Qint 0 1000MEG
D_D10 Qint MY5 D_D1
V1 MY5 0 {VDD}
D_D11 MYVSS Qint D_D1
V2 MYVSS 0 {VSS}
EQ Qqq 0 Qint 0 1
X3 Qqq Qqqd1 BUF_BASIC_GEN PARAMS: VDD={VDD} VSS={VSS} VTHRESH={VTHRESH}
RQq Qqqd1 Q 1
EQb Qbr 0 VALUE = {IF( V(Q) > {VTHRESH}, {VSS},{VDD})}
RQb Qbr QB 1
Cdummy1 Q 0 1n
Cdummy2 QB 0 1n
.IC V(Qint) {VSS}
.ENDS SRLATCHRHP_BASIC_GEN
*$

.SUBCKT BUF_BASIC_GEN A  Y PARAMS: VDD=1 VSS=0 VTHRESH=0.5
E_ABMGATE    YINT 0 VALUE {{IF(V(A) > {VTHRESH} ,
+ {VDD},{VSS})}}
RINT YINT Y 1
CINT Y 0 1n
.ENDS BUF_BASIC_GEN
*$

************************************COMPARTOR**********************************************************
.SUBCKT COMP_BASIC_GEN INP INM Y PARAMS: VDD=1 VSS=0 VTHRESH=0.5
E_ABM Yint 0 VALUE {IF (V(INP) >
+ V(INM), {VDD},{VSS})}
R1 Yint Y 1
C1 Y 0 1n
.ENDS COMP_BASIC_GEN
*$

.SUBCKT BUF_DELAY_BASIC_GEN A  Y PARAMS: VDD=1 VSS=0 VTHRESH=0.5 DELAY = 10n
E_ABMGATE1    YINT1 0 VALUE {{IF(V(A) > {VTHRESH} ,
+ {VDD},{VSS})}}
RINT YINT1 YINT2 1
CINT YINT2 0 {DELAY*1.3}
E_ABMGATE2    YINT3 0 VALUE {{IF(V(YINT2) > {VTHRESH} ,
+ {VDD},{VSS})}}
RINT2 YINT3 Y 1
CINT2 Y 0 1n
.ENDS BUF_DELAY_BASIC_GEN
*$

.SUBCKT COMPHYS_BASIC_GEN INP INM HYS OUT PARAMS: VDD=1 VSS=0 VTHRESH=0.5
EIN INP1 INM1 INP INM 1
EHYS INP1 INP2 VALUE { IF( V(1) > {VTHRESH},-V(HYS),0) }
EOUT OUT 0 VALUE { IF( V(INP2)>V(INM1), {VDD} ,{VSS}) }
R1 OUT 1 1
C1 1 0 5n
RINP1 INP1 0 1K
.ENDS COMPHYS_BASIC_GEN
*$

*$
.SUBCKT LDCR 1 2 PARAMS: L=1u DCR=20m
L1 1 INT1 {L}
R1 INT1 2 {DCR}
.ENDS LDCR
*$
.SUBCKT CESR 1 2 PARAMS: C=10u ESR=2m ESL=1n
C1 1 INT1 {C}
R1 INT1 INT2 {ESR}
L1 INT2 2 {ESL}
.ENDS CESR
*$
Xentry BOOT COMP EN ETPad GND_1 GND_2 PH_1 PH_2 PVIN_1 PVIN_2 PWRGD RT_CLK SS_TR VIN VSENSE TPS54320_TRANS
.ENDS library_simulation_spice_subcircuit_0
CC2 N2 0 4.7U
CC3 N2 0 4.7U
CC4 N5 0 14.999999999999998N
CC5 N8 N7 100N
CC6 N4 0 330P
CC7 N10 0 10N
CC9 VOUT 0 47U
CC11 VOUT N3 100P
LL1 N7 VOUT 6.799999999999999u
RR1 N2 N6 511K
RR2 N6 0 100K
RR3 N1 0 100K
RR4 N4 N10 1.78K
RR8 VOUT N3 31.6K
RR9 N3 0 10K
RRPG VOUT N9 100K
RRLOAD VOUT 0 1.1
Vsimulation_voltage_source_0 N2 0 DC 12
Xsimulation_spice_subcircuit_0 N8 N4 N6 0 0 0 N7 N7 N2 N2 N9 N1 N5 N2 N3 library_simulation_spice_subcircuit_0
* tscircuit_probe {"simulation_voltage_probe_id":"simulation_voltage_probe_0","name":"VOUT","spice_vector":"V(VOUT)","source_node_name":"VOUT"}
.PRINT TRAN V(VOUT)
.SAVE V(VOUT)
.tran 1e-7 50u UIC
.END
