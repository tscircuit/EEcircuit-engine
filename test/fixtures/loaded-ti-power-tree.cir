Loaded TI power tree with simultaneous output load edges
* Exported with tscircuit0.0.3298 and its PSpice compatibility rewrite.
* Model equations and component values retained; trailing whitespace trimmed.
* First 10 us of the original 20 ms analysis, covering both early event failures.
.SUBCKT library_simulation_spice_subcircuit_0 AGND DNC DNC_1 EN_SYNC FB PGND PGND_1 PGND_2 PGND_3 PGOOD RT SW SW_1 SW_2 VIN VOUT VOUT_1 VOUT_2
*$
* LMZM33602
*****************************************************************************
* (C) Copyright 2017 Texas Instruments Incorporated. All rights reserved.
*****************************************************************************
** This model is designed as an aid for customers of Texas Instruments.
** TI and its licensors and suppliers make no warranties, either expressed
** or implied, with respect to this model, including the warranties of
** merchantability or fitness for a particular purpose.  The model is
** provided solely on an "as is" basis.  The entire risk as to its quality
** and performance is with the customer
*****************************************************************************
*
* This model is subject to change without notice. Texas Instruments
* Incorporated is not responsible for updating this model.
*
*****************************************************************************
*
** Released by: WEBENCH Design Center, Texas Instruments Inc.
* Part: LMZM33602
* Date: 27OCT2017
* Model Type: TRANSIENT
* Simulator: PSPICE
* Simulator Version: 16.2.0.p001
* EVM Order Number: LMZM33602EVM
* EVM Users Guide: SNVU565-August 2017
* Datasheet: SNVSAO6 - SEPTEMBER 2017
* Topologies Supported: Buck,Inverting Buck Boost
*
* Model Version: Final 1.00
*
*****************************************************************************
*
* Updates:
*
* Final 1.00
* Release to Web.
*
*****************************************************************************
*
* Model Usage Notes:
*
* 1. The following features have been modeled
*      a. Frequency foldback during soft-start
*      b. Current foldback
*      c. Current limit, Hiccup
*      d. IBB compatible
*      e. PGOOD functionality with Deglitch filter
* 2. The operating quiescent current and thermal shutdown characteristics have not been modeled.
*
*****************************************************************************
.SUBCKT LMZM33602_TRANS AGND DNC DNC_1 EN_SYNC FB PGND PGND_1 PGND_2 PGND_3
+  PGOOD RT SW SW_1 SW_2 VIN VOUT VOUT_1 VOUT_2  PARAMS: MODE=0 IPEAK=5.5 IVALLEY_TH=3.8 ILNEG_TH=2
C_C1         DNC_1 PGND_1  2.2u
L_L1         SW VOUT  6.8uH
C_C2         DNC SW  0.1u IC={mode*5}
E_U1_ABM1         U1_FPWMFORCE 0 VALUE { If(V(U1_VREF)<0.98,0,1)    }
R_U1_R5         U1_N16790946 AGND  1m
R_U1_R6         U1_N16790946 AGND  1m
E_U1_E1         U1_FBI 0 FB PGND 1
C_U1_U1_C2         0 U1_U1_N16765634  13.5p
C_U1_U1_C1         0 U1_COMP  1p
R_U1_U1_R1         U1_FBI U1_U1_N16765634  25k
G_U1_U1_ABM2I1         0 U1_COMP VALUE { LIMIT(IF(V(U1_VREF)>0.98, (V(U1_VREF)
+  - V(U1_U1_N16765634))*14u, (V(U1_VREF) - V(U1_U1_N16765634))*7u),-2.5u,2u)
+  }
V_U1_U1_V6         U1_U1_N16765450 0 1.8
E_U1_U1_ABM2         U1_I_FOLDBACK 0 VALUE { if( V(U1_FPWMFORCE)< 0.5,
+ V(U1_U1_N16765598) ,0)   }
C_U1_U1_C3         0 U1_FBI  100f
E_U1_U1_ABM3         U1_PFM 0 VALUE { IF(V(U1_COMP)<0.25,1,0)    }
D_U1_U1_D10         U1_COMP U1_U1_N16765450 D_D
X_U1_U1_H1    U1_U1_N16765504 U1_COMP U1_U1_N16765466 0
+  ERROR_AMPLIFIER_U1_U1_H1
V_U1_U1_V9         U1_U1_N167658641 0 0.25
X_U1_U1_S1    U1_HICCUP 0 U1_COMP 0 ERROR_AMPLIFIER_U1_U1_S1
D_U1_U1_D9         U1_U1_N167658641 U1_U1_N16765504 D_D
E_U1_U1_ABM1         U1_U1_N16765598 0 VALUE { MAX ( V(U1_U1_N16765466) , 0 )
+   }
C_U1_C4         0 U1_N16789886  50p
V_U1_U2_V1         U1_U2_N16758309 0 1.01
X_U1_U2_F1    U1_U2_N16758379 U1_U2_N16758343 U1_U2_SS_INT 0
+  SOFT_START_U1_U2_F1
G_U1_U2_ABMII1         U1_U2_N16758309 U1_U2_SS_INT VALUE { IF(V(U1_U2_DISCH) >
+  0.5,0,3u)    }
E_U1_U2_ABM7         U1_U2_VREF_FEED 0 VALUE { LIMIT(V(U1_U2_N16758447) ,20m,0)
+     }
R_U1_U2_R2         U1_U2_N16758343 U1_U2_N16758297  1000k
E_U1_U2_ABM5         U1_U2_N16758407 0 VALUE { IF(V(U1_U2_VREF_INT)
+  >0.9,V(U1_U2_VREF_FEED),0)    }
C_U1_U2_C3         0 U1_U2_N16758297  0.4n
E_U1_U2_E2         U1_U2_N16758441 0 VIN 0 0.5
R_U1_U2_R1         0 U1_U2_N16758447  1k
E_U1_U2_E1         U1_VREF U1_U2_N16758407 U1_U2_VREF_INT 0 1
C_U1_U2_C2         U1_U2_N16758447 U1_U2_N16758441  0.1n
X_U1_U2_S1    U1_U2_DISCH 0 U1_U2_SS_INT 0 SOFT_START_U1_U2_S1
X_U1_U2_U3         U1_SDWN U1_HICCUP U1_U2_DISCH OR2_BASIC_GEN PARAMS: VDD=1
+  VSS=0 VTHRESH=500E-3
E_U1_U2_ABM1         U1_U2_VREF_INT 0 VALUE { MIN( V(U1_U2_SS_INT) , 1)    }
E_U1_U2_ABM6         U1_U2_N16758379 0 VALUE { IF( V(U1_U2_DISCH) < 0.5,1, 0)
+   }
D_U1_U2_D62         U1_U2_SS_INT U1_U2_N16758309 D_D1
C_U1_U2_C1         U1_U2_SS_INT 0  18n IC={mode}
V_U1_U7_V9         U1_U7_N16763491 0 3.299
X_U1_U7_U617         U1_U7_EN_OK U1_U7_ENOK_B INV_BASIC_GEN PARAMS: VDD=1 VSS=0
+  VTHRESH=500E-3
X_U1_U7_U614         EN_SYNC U1_U7_N16763401 U1_U7_N16763395 U1_U7_N16763457
+  COMPHYS_BASIC_GEN PARAMS: VDD=1 VSS=0 VTHRESH=0.5
E_U1_U7_ABM3         U1_VCC_I 0 VALUE { IF(V(VIN)>4.1,4.1,V(VIN))    }
V_U1_U7_V8         U1_U7_N16763485 0 0.4
V_U1_U7_V12         U1_U7_N16763453 0
+PULSE {1-MODE} 0 1u 1n 1n 1 2
V_U1_U7_V6         U1_U7_N16763395 0 0.4
V_U1_U7_V7         U1_U7_N16763401 0 1.5499
V_U1_U7_V4         U1_U7_N16763349 0 3.599
X_U1_U7_U618         U1_U7_VCC_OK U1_U7_VCCOK_B INV_BASIC_GEN PARAMS: VDD=1
+  VSS=0 VTHRESH=500E-3
X_U1_U7_U623         U1_U7_N16763457 U1_U7_EN_OK BUF_DELAY_BASIC_GEN PARAMS:
+  VDD=1 VSS=0 VTHRESH=0.5 DELAY=0.7m
X_U1_U7_U613         VIN U1_U7_N16763349 U1_U7_N16763343 U1_U7_VIN_OK
+  COMPHYS_BASIC_GEN PARAMS: VDD=1 VSS=0 VTHRESH=0.5
X_U1_U7_U616         U1_U7_VIN_OK U1_VINOK_B INV_BASIC_GEN PARAMS: VDD=1 VSS=0
+  VTHRESH=500E-3
X_U1_U7_U615         U1_VCC_I U1_U7_N16763491 U1_U7_N16763485 U1_U7_VCC_OK
+  COMPHYS_BASIC_GEN PARAMS: VDD=1 VSS=0 VTHRESH=0.5
X_U1_U7_U622         U1_VINOK_B U1_U7_ENOK_B U1_U7_VCCOK_B U1_U7_N16763453
+  U1_SDWN OR4_BASIC_GEN PARAMS: VDD=1 VSS=0 VTHRESH=500E-3
E_U1_U7_E4         DNC_1 PGND U1_VCC_I 0 1
V_U1_U7_V5         U1_U7_N16763343 0 0.3
C_U1_C6         0 U1_COMP  0.5p
X_U1_U5_U608         U1_U5_N16187 U1_U5_N16177 U1_U5_N16335 AND2_BASIC_GEN
+  PARAMS: VDD=1 VSS=0 VTHRESH=500E-3
X_U1_U5_U609         U1_U5_N16265 U1_U5_N16273 U1_U5_N16239 COMP_BASIC_GEN
+  PARAMS: VDD=1 VSS=0 VTHRESH=0.5
C_U1_U5_C6         0 U1_U5_N16265  14.8n IC=0
C_U1_U5_C5         0 U1_U5_N16187  1n
X_U1_U5_U2_U620         U1_U5_N16541 U1_U5_U2_N00780 U1_U5_U2_N00140
+  OR2_BASIC_GEN PARAMS: VDD=1 VSS=0 VTHRESH=500E-3
X_U1_U5_U2_U618         U1_U5_U2_N00220 U1_U5_U2_N02470 U1_U5_N16587
+  AND2_BASIC_GEN PARAMS: VDD=1 VSS=0 VTHRESH=500E-3
D_U1_U5_U2_D1         U1_U5_N16541 U1_U5_U2_N00780 D_D1
X_U1_U5_U2_U621         U1_U5_U2_N00140 U1_U5_U2_N00220 INV_BASIC_GEN PARAMS:
+  VDD=1 VSS=0 VTHRESH=500E-3
R_U1_U5_U2_R1         U1_U5_N16541 U1_U5_U2_N00780  144.3001443
X_U1_U5_U2_U607         U1_U5_U2_N00140 U1_U5_U2_N03610 INV_DELAY_BASIC_GEN
+  PARAMS: VDD=1 VSS=0 VTHRESH=0.5 DELAY=50n
C_U1_U5_U2_C1         0 U1_U5_U2_N00780  1n
X_U1_U5_U2_U608         U1_U5_U2_N03610 U1_U5_U2_N02470 INV_DELAY_BASIC_GEN
+  PARAMS: VDD=1 VSS=0 VTHRESH=0.5 DELAY=50n
X_U1_U5_U610         U1_U5_N16391 U1_U5_N16611 INV_DELAY_BASIC_GEN PARAMS:
+  VDD=1 VSS=0 VTHRESH=0.5 DELAY=5u
R_U1_U5_R5         U1_U5_N16391 U1_U5_N16381  1
X_U1_U5_U612         U1_U5_N16445 U1_U5_N16453 U1_U5_N16381 COMP_BASIC_GEN
+  PARAMS: VDD=1 VSS=0 VTHRESH=0.5
V_U1_U5_V4         U1_U5_N16453 0 1
E_U1_U5_ABM8         U1_U5_N16143 0 VALUE { IF(V(U1_COMP) > 1.8,1,0)    }
C_U1_U5_C7         0 U1_U5_N16445  10u IC=0
X_U1_U5_U611         U1_U5_N16611 U1_U5_H_END INV_DELAY_BASIC_GEN PARAMS: VDD=1
+  VSS=0 VTHRESH=0.5 DELAY=5u
G_U1_U5_G4         0 U1_U5_N16445 U1_HICCUP 0 1m
G_U1_U5_G3         0 U1_U5_N16265 U1_U5_N16109 0 1
X_U1_U5_U30         U1_U5_N16239 U1_U5_H_END U1_HICCUP U1_U5_HICCUP_N
+  SRLATCHRHP_BASIC_GEN PARAMS: VDD=1 VSS=0 VTHRESH=0.5
X_U1_U5_S4    U1_U5_H_END 0 U1_U5_N16445 0 HICCUP1_U1_U5_S4
X_U1_U5_U616         U1_U5_N16143 U1_CLK U1_U5_HICCUP_N U1_U5_N16109
+  AND3_BASIC_GEN PARAMS: VDD=1 VSS=0 VTHRESH=500E-3
R_U1_U5_R8         U1_U5_N16187 U1_HICCUP  1
X_U1_U5_U607         U1_U5_N16187 U1_U5_N16177 INV_DELAY_BASIC_GEN PARAMS:
+  VDD=1 VSS=0 VTHRESH=0.5 DELAY=10u
E_U1_U5_ABM9         U1_U5_N16541 0 VALUE { {IF(V(U1_COMP) > 1,1,0)}    }
V_U1_U5_V2         U1_U5_N16273 0 64
C_U1_U5_C8         0 U1_U5_N16391  1n
X_U1_U5_U615         U1_U5_N16587 U1_U5_N16335 U1_U5_N16351 OR2_BASIC_GEN
+  PARAMS: VDD=1 VSS=0 VTHRESH=500E-3
X_U1_U5_S3    U1_U5_N16351 0 U1_U5_N16265 0 HICCUP1_U1_U5_S3
X_U1_U4_H1    VIN U1_U4_N140778 U1_U4_N140916 0 Driver_mod_U1_U4_H1
D_U1_U4_D73         U1_U4_N141178 U1_PH1 D_D1
D_U1_U4_D70         U1_U4_N140936 DNC D_D1
E_U1_U4_E2         U1_U4_N140586 0 U1_U4_N140568 0 1
C_U1_U4_C178         0 U1_U4_N140568  1n
D_U1_U4_D69         U1_U4_N140700 U1_PH1 D_D1
E_U1_U4_E_test         U1_U4_BOOT_SW_ON 0 VALUE {
+  IF((V(U1_U4_BOOT_SW_ON_INT)>0.5 & V(U1_SDWN) < 0.5),1,0)    }
R_U1_U4_R11         U1_PH2 U1_U4_N141290  72.15 TC1=0 TC2=0
C_U1_U4_C12         0 U1_U4_L_ISWH  1n
X_U1_U4_U643         U1_U4_LDRV_INT U1_U4_LDRV_INTB U1_PH2 U1_U4_N141426
+  U1_U4_ZCDLRES 0 dffsr_rhpbasic_gen PARAMS: VDD=1 VSS=0 VTHRESH=500E-3
X_U1_U4_U665         U1_FPWMFORCE U1_PH1 U1_U4_N141714 AND2_BASIC_GEN PARAMS:
+  VDD=1 VSS=0 VTHRESH=500E-3
X_U1_U4_S1    U1_HDRV SW U1_U4_N140778 SW Driver_mod_U1_U4_S1
X_U1_U4_U666         U1_U4_N141728 U1_U4_N141714 U1_U4_N140520 AND2_BASIC_GEN
+  PARAMS: VDD=1 VSS=0 VTHRESH=500E-3
C_U1_U4_C11         0 U1_ISWH  1n
X_U1_U4_U644         U1_U4_N141488 U1_U4_N141460 U1_U4_ZCDLRES OR2_BASIC_GEN
+  PARAMS: VDD=1 VSS=0 VTHRESH=500E-3
D_U1_U4_D65         U1_U4_N140910 SW D_D1
X_U1_U4_U651         U1_SDWN U1_U4_N140988 INV_BASIC_GEN PARAMS: VDD=1 VSS=0
+  VTHRESH=500E-3
R_U1_U4_R280         0 U1_U4_ZCDTHRESH  1e9
E_U1_U4_E1         U1_U4_N140544 0 U1_U4_ZCDTHRESH 0 -1
X_U1_U4_U617         U1_U4_N140544 U1_U4_L_ISWH U1_U4_ZCD COMP_BASIC_GEN
+  PARAMS: VDD=1 VSS=0 VTHRESH=0.5
R_U1_U4_R12         U1_PH1 U1_U4_N140700  28.86 TC1=0 TC2=0
X_U1_U4_U663         U1_U4_N141650 U1_U4_N141664 INV_DELAY_BASIC_GEN PARAMS:
+  VDD=1 VSS=0 VTHRESH=0.5 DELAY=40n
X_U1_U4_U650         U1_HICCUP U1_U4_N140796 INV_BASIC_GEN PARAMS: VDD=1 VSS=0
+  VTHRESH=500E-3
X_U1_U4_U648         U1_HDRV_INT U1_U4_N140760 INV_BASIC_GEN PARAMS: VDD=1
+  VSS=0 VTHRESH=500E-3
X_U1_U4_U652         U1_U4_LDRV_INT U1_U4_N140796 U1_U4_N140988 U1_LDRV
+  AND3_BASIC_GEN PARAMS: VDD=1 VSS=0 VTHRESH=500E-3
C_U1_U4_C14         0 U1_U4_N141178  1n  TC=0,0
X_U1_U4_S35    U1_U4_BOOT_SW_ON 0 U1_U4_N140936 U1_VCC_I Driver_mod_U1_U4_S35
X_U1_U4_S2    U1_LDRV 0 SW U1_U4_N140910 Driver_mod_U1_U4_S2
D_U1_U4_D72         U1_U4_N141294 U1_U4_N140568 D_Dton
R_U1_U4_R277         U1_U4_N140568 U1_U4_N141294  144.3
D_U1_U4_D9         U1_U4_VLOWER U1_U4_ZCDTHRESH D_D
X_U1_U4_U645         U1_PH2 U1_U4_N141488 INV_BASIC_GEN PARAMS: VDD=1 VSS=0
+  VTHRESH=500E-3
X_U1_U4_U611         U1_U4_N141290 U1_PH2 U1_L_BLNCK AND2_BASIC_GEN PARAMS:
+  VDD=1 VSS=0 VTHRESH=500E-3
R_U1_U4_R15         U1_PH1 U1_U4_N141178  21.65 TC1=0 TC2=0
X_U1_U4_U615         U1_U4_ZCD U1_L_BLNCK U1_U4_N141460 AND2_BASIC_GEN PARAMS:
+  VDD=1 VSS=0 VTHRESH=500E-3
G_U1_U4_ABMII1         U1_U4_N141752 U1_U4_ZCDTHRESH VALUE {
+  if(V(U1_U4_N140520) >0.5, 350n,0)    }
G_U1_U4_ABMII2         U1_U4_ZCDTHRESH 0 VALUE { if(V(U1_U4_N140526) >0.5,
+  350n,0)    }
D_U1_U4_D10         U1_U4_ZCDTHRESH U1_U4_VUPPER D_D
X_U1_U4_U656         U1_L_BLNCK U1_U4_N138612 U1_U4_N141294 AND2_BASIC_GEN
+  PARAMS: VDD=1 VSS=0 VTHRESH=500E-3
X_U1_U4_H2    U1_U4_N140910 PGND U1_U4_N140904 0 Driver_mod_U1_U4_H2
E_U1_U4_ABM172         U1_U4_N140660 0 VALUE { IF(((V(DNC) - V(SW)) > 2.8), 0 ,
+  1)    }
X_U1_U4_U662         U1_U4_N141664 U1_U4_N141650 U1_U4_N140526 AND2_BASIC_GEN
+  PARAMS: VDD=1 VSS=0 VTHRESH=500E-3
X_U1_U4_S5    U1_U4_N140760 0 U1_HDRV PGND Driver_mod_U1_U4_S5
D_U1_U4_D68         U1_U4_N141290 U1_PH2 D_D1
X_U1_U4_U610         U1_U4_N141178 U1_PH1 U1_HDRV_INT AND2_BASIC_GEN PARAMS:
+  VDD=1 VSS=0 VTHRESH=500E-3
R_U1_U4_R247         U1_U4_L_ISWH U1_U4_N140904  1
C_U1_U4_C8         0 U1_U4_N141290  1n  TC=0,0
X_U1_U4_S4    U1_HDRV_INT 0 DNC U1_HDRV Driver_mod_U1_U4_S4
V_U1_U4_V9         U1_U4_N141752 0 1.2
X_U1_U4_U621         U1_U4_N162176 U1_U4_L_ISWH U1_U4_N138612 COMP_BASIC_GEN
+  PARAMS: VDD=1 VSS=0 VTHRESH=0.5
C_U1_U4_C1         0 U1_U4_ZCDTHRESH  2p
D_U1_U4_D64         SW U1_U4_N140778 D_D1
X_U1_U4_U667         U1_U4_N141714 U1_U4_N141728 INV_DELAY_BASIC_GEN PARAMS:
+  VDD=1 VSS=0 VTHRESH=0.5 DELAY=40n
V_U1_U4_V7         U1_U4_VUPPER 0 {ILNEG_TH}
R_U1_U4_R14         U1_U4_N140660 U1_U4_BOOT_UVLO  1 TC1=0 TC2=0
X_U1_U4_U646         U1_U4_BOOT_UVLO U1_LDRV U1_U4_BOOT_SW_ON_INT OR2_BASIC_GEN
+  PARAMS: VDD=1 VSS=0 VTHRESH=500E-3
V_U1_U4_V4         U1_U4_N162176 0 {IVALLEY_TH}
X_U1_U4_U671         U1_FPWMFORCE U1_U4_N140600 INV_BASIC_GEN PARAMS: VDD=1
+  VSS=0 VTHRESH=500E-3
C_U1_U4_C9         0 U1_U4_N140700  1n  TC=0,0
R_U1_U4_R278         U1_LOK U1_U4_N140586  22
V_U1_U4_V5         U1_U4_N141426 0 1
C_U1_U4_C13         0 U1_U4_BOOT_UVLO  1n  TC=0,0
R_U1_U4_R246         U1_ISWH U1_U4_N140916  1
R_U1_U4_R245         0 DNC  100MEG
V_U1_U4_V8         U1_U4_VLOWER 0 .04
X_U1_U4_U612         U1_U4_N140700 U1_PH1 U1_H_BLNCK AND2_BASIC_GEN PARAMS:
+  VDD=1 VSS=0 VTHRESH=500E-3
X_U1_U4_U675         U1_U4_N140600 U1_PH1 U1_U4_N141650 AND2_BASIC_GEN PARAMS:
+  VDD=1 VSS=0 VTHRESH=500E-3
C_U1_U4_C179         U1_LOK 0  1n
X_U1_U6_U629         U1_CLK U1_U6_N16779278 U1_U6_PH1_1 U1_U6_N16779216
+  SRLATCHRHP_BASIC_GEN PARAMS: VDD=1 VSS=0 VTHRESH=0.5
X_U1_U6_U610         U1_U6_N16780920 U1_U6_N16781026 U1_U6_PG0 COMP_BASIC_GEN
+  PARAMS: VDD=1 VSS=0 VTHRESH=0.5
E_U1_U6_ABM2         U1_U6_N16779190 0 VALUE { V(U1_U6_ISWF)    }
R_U1_U6_R276         U1_U6_N16779141 U1_U6_N16779148  86.58
E_U1_U6_ABM3         U1_U6_VREFTH_HIGH 0 VALUE { (V(U1_U6_N16780843)*1.06)    }
C_U1_U6_C8         0 U1_U6_N16781230  1u IC=0
V_U1_U6_VIN         U1_U6_N16780843 0 1
X_U1_U6_U834         U1_SDWN U1_U6_N16779307 U1_U6_N16779170 U1_U6_PREBIAS
+  SRLATCHRHP_BASIC_GEN PARAMS: VDD=1 VSS=0 VTHRESH=0.5
C_U1_U6_C10         0 U1_U6_PG0  1n IC=0
X_U1_U6_U826         U1_U6_PH1_1 U1_U6_N16779228 INV_DELAY_BASIC_GEN PARAMS:
+  VDD=1 VSS=0 VTHRESH=0.5 DELAY=15n
E_U1_U6_E1         U1_U6_N16779710 0 U1_PH1 0 1
X_U1_U6_U619         U1_U6_VREFTH_HIGH U1_FBI U1_U6_N16781114 U1_U6_N16780905
+  COMPHYS_BASIC_GEN PARAMS: VDD=1 VSS=0 VTHRESH=0.5
G_U1_U6_G4         0 U1_U6_N16781230 U1_U6_ANDOUT1 0 1
E_U1_U6_ABM5         U1_U6_VREFTH_LOW 0 VALUE { (V(U1_U6_N16780879)*0.94)    }
X_U1_U6_U630         U1_U6_N16779157 U1_H_BLNCK U1_U6_N16779347 AND2_BASIC_GEN
+  PARAMS: VDD=1 VSS=0 VTHRESH=500E-3
V_U1_U6_VIN1         U1_U6_N16780879 0 1
R_U1_U6_R3         0 U1_U6_N16779216  1Meg TC1=0 TC2=0
D_U1_U6_D11         U1_U6_TMOD U1_U6_N16779710 D_Dton
V_U1_U6_V9         U1_U6_N16781114 0 0.01
X_U1_U6_S5    U1_U6_N16781223 0 U1_U6_N16781230 0 GmIphase_U1_U6_S5
X_U1_U6_U827         U1_U6_N16779228 U1_U6_PH1_1 U1_U6_N16779141 AND2_BASIC_GEN
+  PARAMS: VDD=1 VSS=0 VTHRESH=500E-3
R_U1_U6_R278         U1_U6_N16779710 U1_U6_TMOD  7.215k
V_U1_U6_V12         U1_U6_N16781157 0 0.01
X_U1_U6_U830         U1_U6_N16780905 U1_U6_N16780869 U1_U6_N16780830
+  AND2_BASIC_GEN PARAMS: VDD=1 VSS=0 VTHRESH=500E-3
X_U1_U6_U612         U1_VREF U1_FBI U1_U6_N16779307 COMP_BASIC_GEN PARAMS:
+  VDD=1 VSS=0 VTHRESH=0.5
C_U1_U6_C179         0 U1_U6_TMOD  1n
X_U1_U6_U620         U1_FBI U1_U6_VREFTH_LOW U1_U6_N16781157 U1_U6_N16780869
+  COMPHYS_BASIC_GEN PARAMS: VDD=1 VSS=0 VTHRESH=0.5
C_U1_U6_C9         0 U1_U6_N16780920  1u IC=0
E_U1_U6_ABM1         U1_U6_ICMD 0 VALUE { LIMIT ( (( V(U1_COMP)-0.25)*6.7)  -
+  V(U1_ISLOPE), IPEAK, 0)    }
X_U1_U6_U829         U1_U6_PH2_1 U1_U6_PREBIAS U1_PH2 AND2_BASIC_GEN PARAMS:
+  VDD=1 VSS=0 VTHRESH=500E-3
R_U1_U6_R4         U1_U6_N16779170 0  1Meg TC1=0 TC2=0
E_U1_U6_ABM154         U1_U6_ANDOUT1 0 VALUE { IF(V(U1_U6_N16780830)>0.5,1,0)
+   }
X_U1_U6_U837         U1_U6_PG1 U1_U6_PG0 U1_U6_PG10 N16780734
+  SRLATCHRHP_BASIC_GEN PARAMS: VDD=1 VSS=0 VTHRESH=0.5
D_U1_U6_D10         U1_U6_N16779141 U1_U6_N16779148 D_Dton
E_U1_U6_ABM155         U1_U6_ANDOUT0 0 VALUE { IF(V(U1_U6_N16780830)<0.5,1,0)
+   }
G_U1_U6_G5         0 U1_U6_N16780920 U1_U6_ANDOUT0 0 1
C_U1_U6_C177         0 U1_U6_N16779148  1n
X_U1_U6_U5         U1_U6_N16779190 U1_U6_ICMD U1_U6_N16779154 COMP_BASIC_GEN
+  PARAMS: VDD=1 VSS=0 VTHRESH=0.5
X_U1_U6_S6    U1_U6_N16780982 0 U1_U6_N16780920 0 GmIphase_U1_U6_S6
D_U1_U6_D13         U1_U6_N16780742 PGOOD D_Dton
R_U1_U6_R277         U1_U6_N16779154 U1_U6_N16779157  1
E_U1_U6_ABM153         U1_U6_N16779326 0 VALUE {
+  IF(V(U1_PFM)>0.5,V(U1_U6_TMOD),0)    }
X_U1_U6_U831         U1_U6_ANDOUT1 U1_U6_N16781223 INV_BASIC_GEN PARAMS: VDD=1
+  VSS=0 VTHRESH=500E-3
X_U1_U6_U825         U1_U6_N16779141 U1_U6_N16779148 U1_U6_PH1_1 U1_PH1
+  OR3_BASIC_GEN PARAMS: VDD=1 VSS=0 VTHRESH=500E-3
X_U1_U6_U835         U1_U6_N16779326 U1_U6_N16779347 U1_U6_N16779278
+  OR2_BASIC_GEN PARAMS: VDD=1 VSS=0 VTHRESH=500E-3
I_U1_U6_I2 PGOOD U1_U6_N16780742 DC 1m
E_U1_U6_ABM152         U1_U6_ISWF 0 VALUE { {IF(V(U1_HDRV_INT) > 0.5,
+ V(U1_ISWH),0)}   }
V_U1_U6_V2         U1_U6_N16781248 0 150
V_U1_U6_V3         U1_U6_N16781026 0 18
C_U1_U6_C178         0 U1_U6_N16779157  1n
X_U1_U6_S7    U1_U6_PG10 0 U1_U6_N16780742 0 GmIphase_U1_U6_S7
X_U1_U6_U832         U1_U6_ANDOUT0 U1_U6_N16780982 INV_BASIC_GEN PARAMS: VDD=1
+  VSS=0 VTHRESH=500E-3
X_U1_U6_U609         U1_U6_N16781230 U1_U6_N16781248 U1_U6_PG1 COMP_BASIC_GEN
+  PARAMS: VDD=1 VSS=0 VTHRESH=0.5
X_U1_U6_U828         U1_PH1 U1_U6_PH2_1 INV_BASIC_GEN PARAMS: VDD=1 VSS=0
+  VTHRESH=500E-3
C_U1_U6_C7         0 U1_U6_PG1  1n IC=0
E_U1_U3_ABM18         U1_U3_CLK_CURRENT 0 VALUE { IF(V(U1_U3_SLOPE_CH) >0.5,(
+  V(U1_U3_N16895037) - V(U1_U3_N16895053))/30,
+  (V(U1_U3_N16895037) - V(U1_U3_N16895053)))   }
X_U1_U3_U157         U1_I_FOLDBACK U1_U3_N16874354 U1_U3_ADDRAMP COMP_BASIC_GEN
+  PARAMS: VDD=1 VSS=0 VTHRESH=0.5
C_U1_U3_C79         U1_U3_RAMP 0  10p IC=0
R_U1_U3_R6         U1_U3_N16869766 U1_U3_RAMPMUL  1m
I_U1_U3_I1         U1_U3_N16887592 RT DC 10udc
R_U1_U3_R7         U1_I_FOLDBACK U1_U3_FOLD_FILT  100k TC1=0 TC2=0
X_U1_U3_U143         U1_U3_N16869535 U1_U3_CLK_SYNC one_shot PARAMS:  T=30
C_U1_U3_C1         U1_U3_N16756738 U1_U3_N16756744  1n
C_U1_U3_C150         U1_U3_RAMPMUL 0  10u
D_U1_U3_D64         RT U1_U3_N16887592 D_D1
X_U1_U3_U145         U1_U3_N16845235 U1_U3_N16845117 U1_CLK AND2_BASIC_GEN
+  PARAMS: VDD=1 VSS=0 VTHRESH=500E-3
V_U1_U3_V8         U1_U3_N168794300 0 1
E_U1_U3_E6         U1_U3_N16895034 0 RT PGND 1
E_U1_U3_ABM12         U1_U3_SYNC_ISLOPE 0 VALUE { if ( V(U1_U3_N16870601)<0.5,
+
+ 0
+ , V(U1_U3_INT_ISLOPE)/(1m+V(U1_U3_RAMPMUL)) )  }
C_U1_U3_C149         U1_U3_CLK_INT_DISABLE 0  1n IC=0 TC=0,0
X_U1_U3_U677         U1_U3_SYNC_VINB U1_U3_CLK_INT_DISABLE U1_U3_SYNC_SDWNB
+  U1_U3_CLK_SYNC_EN AND3_BASIC_GEN PARAMS: VDD=1 VSS=0 VTHRESH=500E-3
V_U1_U3_V48         U1_U3_N16887592 0 5Vdc
D_U1_U3_D62         0 U1_U3_N16756744 D_D1
G_U1_U3_ABM2I5         U1_U3_N40138 U1_U3_N16845134 VALUE {
+  if(V(U1_U3_CLK_SYNC_EN)<0.5,V(U1_U3_CLK_CURRENT),4u)    }
X_U1_U3_U1         U1_U3_N16868915 VIN U1_U3_N168794300 U1_U3_SYNC_VINB
+  COMPHYS2_BASIC_GEN PARAMS: VDD=1 VSS=0 VTHRESH=0.5 T=10
X_U1_U3_U131         U1_U3_RAMP U1_U3_N16845023 U1_U3_SLOPE_CH COMP_BASIC_GEN
+  PARAMS: VDD=1 VSS=0 VTHRESH=0.5
X_U1_U3_U138         U1_LOK U1_HDRV U1_U3_N16845062 U1_U3_N16845571
+  SRLATCHRHP_BASIC_GEN PARAMS: VDD=1 VSS=0 VTHRESH=0.5
E_U1_U3_ABM16         U1_U3_N16895053 0 VALUE { V(U1_I_FOLDBACK)*20    }
R_U1_U3_R1         U1_U3_N16845030 U1_CLK  15 TC1=0 TC2=0
D_U1_U3_D14         0 U1_U3_N16845134 D_D1
R_U1_U3_R2         U1_U3_N16756744 0  1k
V_U1_U3_V7         U1_U3_N16868915 0 21
C_U1_U3_C148         0 U1_U3_N16845030  1n  TC=0,0
E_U1_U3_ABM14         U1_U3_SYNC_SDWNB 0 VALUE { IF(V(U1_VREF)>0.98*1,1,0)    }
X_U1_U3_U140         U1_U3_N16845062 U1_U3_SLOPE_CH U1_U3_N16845113
+  AND2_BASIC_GEN PARAMS: VDD=1 VSS=0 VTHRESH=500E-3
X_U1_U3_U153         U1_U3_N16869535 U1_U3_CLK_SAM one_shot PARAMS:  T=10
D_U1_U3_D11         U1_U3_N16845134 U1_U3_N40138 D_D1
R_U1_U3_R5         U1_U3_N16775751 U1_U3_CLK_INT_DISABLE  8k TC1=0 TC2=0
E_U1_U3_ABM6         U1_U3_SYNC_INT 0 VALUE { If(V(U1_U3_SYNC_INT) <0.5,
+  If(V(U1_U3_N16756744)>2.79, 1, 0), If(V(U1_U3_N16756744)>0.1, 1, 0))     }
X_U1_U3_U156         U1_U3_SYNC_INT U1_U3_N16869535 BUF_DELAY_BASIC_GEN PARAMS:
+  VDD=1 VSS=0 VTHRESH=0.5 DELAY=100n
E_U1_U3_ABM13         U1_U3_N16874354 0 VALUE { if(V(U1_U3_FOLD_FILT)> 0.05u,
+  V(U1_U3_FOLD_FILT)*1.9,1)    }
G_U1_U3_ABM2I2         U1_U3_N40138 U1_U3_RAMP VALUE { if(V(U1_U3_ADDRAMP) >0.5
+  & V(U1_PH2)<0.5, 4u,0)    }
D_U1_U3_D15         U1_U3_N16845134 U1_U3_RAMP D_D1
X_U1_U3_U154         U1_U3_CLK_SYNC_EN U1_U3_N16870601 BUF_DELAY_BASIC_GEN
+  PARAMS: VDD=1 VSS=0 VTHRESH=0.5 DELAY=2u
V_U1_U3_V45         U1_U3_N40138 0 10
X_U1_U3_U146         U1_HICCUP U1_SDWN U1_U3_N16845117 NOR2_BASIC_GEN PARAMS:
+  VDD=1 VSS=0 VTHRESH=500E-3
E_U1_U3_E2         U1_U3_N16870068 0 U1_U3_RAMP 0 1
R_U1_U3_R4         0 U1_U3_N16845571  1Meg TC1=0 TC2=0
C_U1_U3_C151         U1_U3_FOLD_FILT 0  1n  TC=0,0
V_U1_U3_V47         U1_U3_N16845023 0 1
X_U1_U3_S27    U1_U3_CLK_SAM 0 U1_U3_N16870068 U1_U3_N16869766
+  Oscillator_U1_U3_S27
X_U1_U3_S26    U1_U3_DISCHARGE 0 U1_U3_RAMP 0 Oscillator_U1_U3_S26
E_U1_U3_E3         U1_U3_N16756738 0 EN_SYNC PGND 1
E_U1_U3_E4         U1_U3_N16775751 0 U1_U3_CLK_SYNC 0 1
X_U1_U3_U142         U1_U3_N16845113 U1_U3_CLK_SYNC U1_U3_CLK_SYNC_EN
+  U1_U3_N16845235 MUX2_BASIC_GEN PARAMS: VDD=1 VSS=0 VTHRESH=0.5
D_U1_U3_D1         U1_U3_N16775751 U1_U3_CLK_INT_DISABLE D_D1
E_U1_U3_ABM22         U1_U3_N16895037 0 VALUE { {IF(V(U1_SDWN)
+  <0.5,IF(V(RT)<3,((V(U1_VREF)*((402u/((100*V(U1_U3_N16895034))+0.6))-0.5u))+0.5u),3.5u*V(U1_VREF)+0.5u),0)}
+     }
X_U1_U3_U155         U1_U3_INT_ISLOPE U1_U3_SYNC_ISLOPE U1_U3_CLK_SYNC_EN
+  U1_ISLOPE MUX2_BASIC_GEN PARAMS: VDD=1 VSS=0 VTHRESH=0.5
E_U1_U3_ABM7         U1_U3_INT_ISLOPE 0 VALUE { V(U1_U3_RAMP)*6.7*0.308    }
X_U1_U3_U137         U1_VINOK_B U1_U3_N16845030 U1_U3_DISCHARGE OR2_BASIC_GEN
+  PARAMS: VDD=1 VSS=0 VTHRESH=500E-3
R_U1_R4         U1_N16789886 U1_COMP  375k
C_C3         VIN PGND  0.1u
.IC         V(U1_COMP)=0
.ENDS LMZM33602_TRANS
*$
.subckt ERROR_AMPLIFIER_U1_U1_H1 1 2 3 4
H_U1_U1_H1         3 4 VH_U1_U1_H1 1
VH_U1_U1_H1         1 2 0V
.ends ERROR_AMPLIFIER_U1_U1_H1
*$
.subckt ERROR_AMPLIFIER_U1_U1_S1 1 2 3 4
S_U1_U1_S1         3 4 1 2 _U1_U1_S1
RS_U1_U1_S1         1 2 1G
.MODEL         _U1_U1_S1 VSWITCH Roff=1.409e9 Ron=3k Voff=0.25V Von=0.75V
.ends ERROR_AMPLIFIER_U1_U1_S1
*$
.subckt SOFT_START_U1_U2_F1 1 2 3 4
F_U1_U2_F1         3 4 VF_U1_U2_F1 1.2
VF_U1_U2_F1         1 2 0V
.ends SOFT_START_U1_U2_F1
*$
.subckt SOFT_START_U1_U2_S1 1 2 3 4
S_U1_U2_S1         3 4 1 2 _U1_U2_S1
RS_U1_U2_S1         1 2 1G
.MODEL         _U1_U2_S1 VSWITCH Roff=1e9 Ron=3k Voff=0.2 Von=0.5
.ends SOFT_START_U1_U2_S1
*$
.subckt HICCUP1_U1_U5_S4 1 2 3 4
S_U1_U5_S4         3 4 1 2 _U1_U5_S4
RS_U1_U5_S4         1 2 1G
.MODEL         _U1_U5_S4 VSWITCH Roff=1e6 Ron=1m Voff=0.25 Von=0.8
.ends HICCUP1_U1_U5_S4
*$
.subckt HICCUP1_U1_U5_S3 1 2 3 4
S_U1_U5_S3         3 4 1 2 _U1_U5_S3
RS_U1_U5_S3         1 2 1G
.MODEL         _U1_U5_S3 VSWITCH Roff=1e6 Ron=1.0 Voff=0.25 Von=0.75
.ends HICCUP1_U1_U5_S3
*$
.subckt Driver_mod_U1_U4_H1 1 2 3 4
H_U1_U4_H1         3 4 VH_U1_U4_H1 1
VH_U1_U4_H1         1 2 0V
.ends Driver_mod_U1_U4_H1
*$
.subckt Driver_mod_U1_U4_S1 1 2 3 4
S_U1_U4_S1         3 4 1 2 _U1_U4_S1
RS_U1_U4_S1         1 2 1G
.MODEL         _U1_U4_S1 VSWITCH Roff=1e9 Ron=160m Voff=0.2 Von=0.5
.ends Driver_mod_U1_U4_S1
*$
.subckt Driver_mod_U1_U4_S35 1 2 3 4
S_U1_U4_S35         3 4 1 2 _U1_U4_S35
RS_U1_U4_S35         1 2 1G
.MODEL         _U1_U4_S35 VSWITCH Roff=10e6 Ron=1 Voff=0.2 Von=0.8
.ends Driver_mod_U1_U4_S35
*$
.subckt Driver_mod_U1_U4_S2 1 2 3 4
S_U1_U4_S2         3 4 1 2 _U1_U4_S2
RS_U1_U4_S2         1 2 1G
.MODEL         _U1_U4_S2 VSWITCH Roff=1e9 Ron=95m Voff=0.2 Von=0.5
.ends Driver_mod_U1_U4_S2
*$
.subckt Driver_mod_U1_U4_H2 1 2 3 4
H_U1_U4_H2         3 4 VH_U1_U4_H2 -1
VH_U1_U4_H2         1 2 0V
.ends Driver_mod_U1_U4_H2
*$
.subckt Driver_mod_U1_U4_S5 1 2 3 4
S_U1_U4_S5         3 4 1 2 _U1_U4_S5
RS_U1_U4_S5         1 2 1G
.MODEL         _U1_U4_S5 VSWITCH Roff=1e6 Ron=2 Voff=0.2 Von=0.8
.ends Driver_mod_U1_U4_S5
*$
.subckt Driver_mod_U1_U4_S4 1 2 3 4
S_U1_U4_S4         3 4 1 2 _U1_U4_S4
RS_U1_U4_S4         1 2 1G
.MODEL         _U1_U4_S4 VSWITCH Roff=1e6 Ron=2 Voff=0.2 Von=0.8
.ends Driver_mod_U1_U4_S4
*$
.subckt GmIphase_U1_U6_S5 1 2 3 4
S_U1_U6_S5         3 4 1 2 _U1_U6_S5
RS_U1_U6_S5         1 2 1G
.MODEL         _U1_U6_S5 VSWITCH Roff=1e6 Ron=1m Voff=0.25 Von=0.5
.ends GmIphase_U1_U6_S5
*$
.subckt GmIphase_U1_U6_S6 1 2 3 4
S_U1_U6_S6         3 4 1 2 _U1_U6_S6
RS_U1_U6_S6         1 2 1G
.MODEL         _U1_U6_S6 VSWITCH Roff=1e6 Ron=1m Voff=0.25 Von=0.5
.ends GmIphase_U1_U6_S6
*$
.subckt GmIphase_U1_U6_S7 1 2 3 4
S_U1_U6_S7         3 4 1 2 _U1_U6_S7
RS_U1_U6_S7         1 2 1G
.model _U1_U6_S7 VSWITCH (roff={max(1e6,1)} ron={min(1e6,1)} voff={if(1e6>1,0.8,0.2)} von={if(1e6>1,0.2,0.8)})
.ends GmIphase_U1_U6_S7
*$
.subckt Oscillator_U1_U3_S27 1 2 3 4
S_U1_U3_S27         3 4 1 2 _U1_U3_S27
RS_U1_U3_S27         1 2 1G
.MODEL         _U1_U3_S27 VSWITCH Roff=1e9 Ron=1m Voff=0.25V Von=0.75V
.ends Oscillator_U1_U3_S27
*$
.subckt Oscillator_U1_U3_S26 1 2 3 4
S_U1_U3_S26         3 4 1 2 _U1_U3_S26
RS_U1_U3_S26         1 2 1G
.MODEL         _U1_U3_S26 VSWITCH Roff=1e9 Ron=1m Voff=0.2 Von=0.8
.ends Oscillator_U1_U3_S26
*$
.model D_D d
+ is=1e-015
+ n=0.01
+ tt=1e-011
+ rs=0.05
*$
.model D_D1 d
+ is=1e-015
+ tt=1e-011
+ rs=0.05
+ n=0.1
*$
.subckt dffsr_rhpbasic_gen q qb clk d r s params: vdd=1 vss=0 vthresh=0.5
x1 clk clkdel1 inv_basic_gen params: vdd={vdd} vss={vss} vthresh={vthresh}
r_clk clkdel1 clkdel 21.64502165
c_clk clkdel 0 1n
x2 clk clkdel clkint and2_basic_gen params: vdd={vdd} vss={vss} vthresh=
+ {vthresh}
gq 0 qint value = {if(v(r) > {vthresh},-5,if(v(s) > {vthresh},5, if(v(clkint)>
+  {vthresh},
+ if(v(d)> {vthresh},5,-5),0)))}
cqint qint 0 1n
d_d10 qint my5 d_d1
v1 my5 0 {vdd}
d_d11 myvss qint d_d1
v2 myvss 0 {vss}
eq qqq 0 qint 0 1
x3 qqq qqqd1 buf_delay_basic_gen params: vdd={vdd} vss={vss} vthresh={vthresh}
+  delay = 1n
rqq qqqd1 q 1
eqb qbr 0 value = {if( v(q) > {vthresh}, {vss},{vdd})}
rqb qbr qb 1
cdummy1 q 0 1nf
cdummy2 qb 0 1nf
.ic v(qint) {vss}
.model d_d1 d
+ is=1e-015
+ tt=1e-011
+ rs=0.05
+ n=0.1
.ends dffsr_rhpbasic_gen
*$
.model D_Dton d
+ is=1e-015
+ tt=1e-011
+ rs=0.005
+ n=0.01
*$
.subckt one_shot in out
+ params:  t=100
s_s1         meas 0 reset2 0 s1
e_abm1         ch 0 value { if( v(in)>0.5 | v(out)>0.5,1,0)    }
r_r2         reset2 reset  0.1
e_abm3         out 0 value { if( v(meas)<0.5 & v(ch)>0.5,1,0)    }
r_r1         meas ch  {t}
c_c2         0 reset2  1.4427n
c_c1         0 meas  1.4427n
e_abm2         reset 0 value { if(v(ch)<0.5,1,0)    }
.model s1 vswitch
+ roff=1e+009
+ ron=1
+ voff=0.25
+ von=0.75
.ends one_shot
*$
.SUBCKT OR2_BASIC_GEN A B Y PARAMS: VDD=1 VSS=0 VTHRESH=0.5
E_ABMGATE    YINT 0 VALUE {{IF(V(A) > {VTHRESH}  |
+ V(B) > {VTHRESH},{VDD},{VSS})}}
RINT YINT Y 1
CINT Y 0 1n
.ENDS OR2_BASIC_GEN
*$
.SUBCKT INV_BASIC_GEN A  Y PARAMS: VDD=1 VSS=0 VTHRESH=0.5
E_ABMGATE    YINT 0 VALUE {{IF(V(A) > {VTHRESH} ,
+ {VSS},{VDD})}}
RINT YINT Y 1
CINT Y 0 1n
.ENDS INV_BASIC_GEN
*$
.SUBCKT COMPHYS_BASIC_GEN INP INM HYS OUT PARAMS: VDD=1 VSS=0 VTHRESH=0.5
EIN INP1 INM1 INP INM 1
EHYS INP1 INP2 VALUE { IF( V(1) > {VTHRESH},-V(HYS),0) }
EOUT OUT 0 VALUE { IF( V(INP2)>V(INM1), {VDD} ,{VSS}) }
R1 OUT 1 1
C1 1 0 1n
RINP1 INP1 0 1K
.ENDS COMPHYS_BASIC_GEN
*$
.SUBCKT BUF_DELAY_BASIC_GEN A  Y PARAMS: VDD=1 VSS=0 VTHRESH=0.5 DELAY = 10n
E_ABMGATE1    YINT1 0 VALUE {{IF(V(A) > {VTHRESH} ,
+ {VDD},{VSS})}}
RINT YINT1 YINT2 1
CINT YINT2 0 {DELAY*1.443}
E_ABMGATE2    YINT3 0 VALUE {{IF(V(YINT2) > {VTHRESH} ,
+ {VDD},{VSS})}}
RINT2 YINT3 Y 1
CINT2 Y 0 1n
.ENDS BUF_DELAY_BASIC_GEN
*$
.SUBCKT OR4_BASIC_GEN A B C D Y PARAMS: VDD=1 VSS=0 VTHRESH=0.5
E_ABMGATE    YINT 0 VALUE {{IF(V(A) > {VTHRESH}  |
+ V(B) > {VTHRESH} |
+ V(C) > {VTHRESH} |
+ V(D) > {VTHRESH},{VDD},{VSS})}}
RINT YINT Y 1
CINT Y 0 1n
.ENDS OR4_BASIC_GEN
*$
.SUBCKT AND2_BASIC_GEN A B Y PARAMS: VDD=1 VSS=0 VTHRESH=0.5
E_ABMGATE    YINT 0 VALUE {{IF(V(A) > {VTHRESH}  &
+ V(B) > {VTHRESH},{VDD},{VSS})}}
RINT YINT Y 1
CINT Y 0 1n
.ENDS AND2_BASIC_GEN
*$
.SUBCKT COMP_BASIC_GEN INP INM Y PARAMS: VDD=1 VSS=0 VTHRESH=0.5
E_ABM Yint 0 VALUE {IF (V(INP) >
+ V(INM), {VDD},{VSS})}
R1 Yint Y 1
C1 Y 0 1n
.ENDS COMP_BASIC_GEN
*$
.SUBCKT INV_DELAY_BASIC_GEN A  Y PARAMS: VDD=1 VSS=0 VTHRESH=0.5 DELAY = 10n
E_ABMGATE1    YINT1 0 VALUE {{IF(V(A) > {VTHRESH} ,
+ {VDD},{VSS})}}
RINT YINT1 YINT2 1
CINT YINT2 0 {DELAY*1.3}
E_ABMGATE2    YINT3 0 VALUE {{IF(V(YINT2) > {VTHRESH} ,
+ {VSS},{VDD})}}
RINT2 YINT3 Y 1
CINT2 Y 0 1n
.ENDS INV_DELAY_BASIC_GEN
*$
.SUBCKT SRLATCHRHP_BASIC_GEN S R Q QB PARAMS: VDD=1 VSS=0 VTHRESH=0.5
GQ 0 Qint VALUE = {IF(V(R) > {VTHRESH},-5,IF(V(S)>{VTHRESH},5, 0))}
CQint Qint 0 1n
RQint Qint 0 1000MEG
D_D10 Qint MY5 D_D1
V1 MY5 0 {VDD}
D_D11 MYVSS Qint D_D1
V2 MYVSS 0 {VSS}
EQ Qqq 0 Qint 0 1
X3 Qqq Qqqd1 BUF_BASIC_GEN PARAMS: VDD={VDD} VSS={VSS} VTHRESH={VTHRESH}
RQq Qqqd1 Q 1
EQb Qbr 0 VALUE = {IF( V(Q) > {VTHRESH}, {VSS},{VDD})}
RQb Qbr QB 1
Cdummy1 Q 0 1n
Cdummy2 QB 0 1n
.IC V(Qint) {VSS}
.ENDS SRLATCHRHP_BASIC_GEN
*$
.SUBCKT AND3_BASIC_GEN A B C Y PARAMS: VDD=1 VSS=0 VTHRESH=0.5
E_ABMGATE    YINT 0 VALUE {{IF(V(A) > {VTHRESH}  &
+ V(B) > {VTHRESH} &
+ V(C) > {VTHRESH},{VDD},{VSS})}}
RINT YINT Y 1
CINT Y 0 1n
.ENDS AND3_BASIC_GEN
*$
.SUBCKT OR3_BASIC_GEN A B C Y PARAMS: VDD=1 VSS=0 VTHRESH=0.5
E_ABMGATE    YINT 0 VALUE {{IF(V(A) > {VTHRESH}  |
+ V(B) > {VTHRESH} |
+ V(C) > {VTHRESH},{VDD},{VSS})}}
RINT YINT Y 1
CINT Y 0 1n
.ENDS OR3_BASIC_GEN
*$
.SUBCKT COMPHYS2_BASIC_GEN INP INM HYS OUT PARAMS: VDD=1 VSS=0 VTHRESH=0.5
+ T=10
EIN INP1 INM1 INP INM 1
EHYS INM2 INM1 VALUE { IF( V(1) > {VTHRESH},-V(HYS)/2,V(HYS)/2) }
EOUT OUT 0 VALUE { IF( V(INP1)>V(INM2), {VDD} ,{VSS}) }
R1 OUT 1 1
C1 1 0 {T*1e-9}
RINP1 INP1 0 10K
RINM2 INM2 0 10K
.ENDS COMPHYS2_BASIC_GEN
*$
.SUBCKT NOR2_BASIC_GEN A B Y PARAMS: VDD=1 VSS=0 VTHRESH=0.5
E_ABMGATE    YINT 0 VALUE {{IF(V(A) > {VTHRESH}  |
+ V(B) > {VTHRESH},{VSS},{VDD})}}
RINT YINT Y 1
CINT Y 0 1n
.ENDS NOR2_BASIC_GEN
*$
.SUBCKT MUX2_BASIC_GEN A B S Y PARAMS: VDD=1 VSS=0 VTHRESH=0.5
E_ABMGATE  YINT 0 VALUE {{IF(V(S) > {VTHRESH},
+ V(B),V(A))}}
RINT YINT Y 1
CINT Y 0 1n
.ENDS MUX2_BASIC_GEN
*$
.SUBCKT BUF_BASIC_GEN A  Y PARAMS: VDD=1 VSS=0 VTHRESH=0.5
E_ABMGATE    YINT 0 VALUE {{IF(V(A) > {VTHRESH} ,
+ {VDD},{VSS})}}
RINT YINT Y 1
CINT Y 0 1n
.ENDS BUF_BASIC_GEN
*$
.SUBCKT CESR IN OUT
+ PARAMs:  C=100u ESR=0.01 X=2 IC=0
C	IN 1  {C*X} IC={IC}
RESR	1 OUT {ESR/X}
.ENDS CESR
*$

Xentry AGND DNC DNC_1 EN_SYNC FB PGND PGND_1 PGND_2 PGND_3 PGOOD RT SW SW_1 SW_2 VIN VOUT VOUT_1 VOUT_2 LMZM33602_TRANS
.ENDS library_simulation_spice_subcircuit_0
.SUBCKT library_simulation_spice_subcircuit_1 EN PAD FB GND PG SS_TR VIN VOUT_0 VOUT_1
*$
* TPS82130
*****************************************************************************
* (C) Copyright 2020 Texas Instruments Incorporated. All rights reserved.
*****************************************************************************
** This model is designed as an aid for customers of Texas Instruments.
** TI and its licensors and suppliers make no warranties, either expressed
** or implied, with respect to this model, including the warranties of
** merchantability or fitness for a particular purpose.  The model is
** provided solely on an "as is" basis.  The entire risk as to its quality
** and performance is with the customer
*****************************************************************************
*
* This model is subject to change without notice. Texas Instruments
* Incorporated is not responsible for updating this model.
*
*****************************************************************************
*
** Released by: Texas Instruments Inc.
* Part: TPS82130
* Date: 28FEB2020
* Model Type: TRANSIENT
* Simulator: PSPICE
* Simulator Version: 17.4-2019 S003
* EVM Order Number: TPS82130EVM-720 (PWR720-001)
* EVM Users Guide: SLVUAK3B�February 2016�Revised May 2017
* Datasheet: SLVSCY5D �FEBRUARY 2016�REVISED NOVEMBER 2018
* Topologies Supported: Buck, Inverting Buck Boost
*
* Model Version: Final 1.20
*
*****************************************************************************
*
* Updates:
*
* Final 1.20
* Model modifications to support Buck, Inverting Buck Boost configuration.
* Soft Start functionality has been changed and modelled as per datasheet description.
*
* Final 1.10
* PGOOD functionality has been changed and modelled as per datasheet description.
*
* Final 1.00
* Release to Web.
*
*****************************************************************************
*
* Model Usage Notes:
*
* 1. The following features have been modeled
*      a. Switching Characteristics
*      b. RON variation with VIN
*      c. Programmable softstart
*      d. Powergood and Current limit
*	   e. SS: The parameter SS has been used to reach the steady state faster.
* 		  Keep SS = 0 to observe startup behaviour and SS = 1 for faster Steady state.
* 2. Temperature effects are not modeled.
*
*****************************************************************************
.SUBCKT TPS82130_TRANS EN PAD FB GND PG SS_TR VIN VOUT_0 VOUT_1 PARAMS: SS=0
V_U3_V5         U3_N11301 0 1.2
I_U3_I1         U3_N11301 U3_N10915 DC 6.4u
X_U3_U10         U3_N10915 U3_N11301 d_d1
X_U3_U11         DRVL_PRE U3_N12733 INV_BASIC_GEN PARAMS: VDD=1 VSS=0
+  VTHRESH=500E-3
C_U3_C2         0 U3_N10915  480f
X_U3_S1    U3_N12733 0 U3_N10915 0 Mintoff_U3_S1
X_U3_U9         U3_N14024 U3_N10915 MIN_TOFF COMP_BASIC_GEN PARAMS: VDD=1 VSS=0
+  VTHRESH=0.5
V_U3_V4         U3_N14024 0 667m
R_R17         N2792911 IAVG  20k
X_U6_U17         U6_N16592 U6_N17195 d_d1
X_U6_U20         U6_N16390 U6_N16592 U6_N26794 PAUSE AND3_BASIC_GEN PARAMS:
+  VDD=1 VSS=0 VTHRESH=500E-3
V_U6_V1         U6_N23722 0 1.5m
C_U6_C4         0 U6_N16592  1n
X_U6_U19         VIN U6_N25747 U6_N26794 COMP_BASIC_GEN PARAMS: VDD=1 VSS=0
+  VTHRESH=0.5
X_U6_U18         DRVH_PRE DRVL_PRE U6_N17195 NOR2_BASIC_GEN PARAMS: VDD=1 VSS=0
+  VTHRESH=500E-3
E_U6_ABM1         U6_N26428 0 VALUE { (V(VOSI) * 1.15)    }
X_U6_U14         U6_N16278410 DRVH_PRE CAPRIO N16285895 srlatchrhp_basic_gen
+  PARAMS: VDD=1 VSS=0 VTHRESH=0.5
R_U6_R4         U6_N26428 U6_N25747  1
X_U6_U5         U6_N23722 ISENSE_LS U6_N75955 COMP_BASIC_GEN PARAMS: VDD=1
+  VSS=0 VTHRESH=0.5
R_U6_R3         U6_N17195 U6_N16592  1.44k
X_U6_U3         DRVL_PRE U6_N75955 U6_N16278410 AND2_BASIC_GEN PARAMS: VDD=1
+  VSS=0 VTHRESH=500E-3
X_U6_U16         MODE_LOGIC U6_N16390 INV_BASIC_GEN PARAMS: VDD=1 VSS=0
+  VTHRESH=500E-3
C_U6_C5         0 U6_N25747  1n
E_U5_ABM4         U5_N20257 0 VALUE { 3.2    }
X_U5_U17         UVLO_OUT EN_LOGIC SDWN_N AND2_BASIC_GEN PARAMS: VDD=1 VSS=0
+  VTHRESH=500E-3
X_U5_U15         U5_N38320 CLIMIT_LS BUF_BASIC_GEN PARAMS: VDD=1 VSS=0
+  VTHRESH=0.5
R_U5_R5         U5_N20257 U5_LSLIMIT_THRESH  1
X_U5_U3         ISENSE_HS U5_HSLIMIT_THRESH U5_N36255 COMP_BASIC_GEN PARAMS:
+  VDD=1 VSS=0 VTHRESH=0.5
R_U5_R10         U5_N478281 U5_HSLIMIT_THRESH  1
C_U5_C5         0 U5_LSLIMIT_THRESH  1n
C_U5_C10         0 U5_HSLIMIT_THRESH  1n
R_U5_R6         U5_N500741 U5_N49148  1
E_U5_ABM2         U5_N145201 0 VALUE { (V(U5_N06443) + 2.9)    }
X_U5_U1         U5_LSLIMIT_THRESH ISENSE_LS U5_N25875 COMP_BASIC_GEN PARAMS:
+  VDD=1 VSS=0 VTHRESH=0.5
R_U5_R3         U5_N145201 U5_N03743  1
C_U5_C3         0 U5_N03743  1n
E_U5_ABM5         U5_N478281 0 VALUE { IF(V(VOSI) < 0.5, 1.8,
+ V(U5_N49148))   }
X_U5_U5         VIN U5_N03743 UVLO_OUT COMP_BASIC_GEN PARAMS: VDD=1 VSS=0
+  VTHRESH=0.5
X_U5_U16         PAUSE DRVL_PRE U5_CL_MASK N47303 srlatchrhp_basic_gen PARAMS:
+  VDD=1 VSS=0 VTHRESH=0.5
X_U5_U2         DRVL_PRE U5_N25875 U5_N38308 AND2_BASIC_GEN PARAMS: VDD=1 VSS=0
+  VTHRESH=500E-3
R_U5_R2         U5_N06376 U5_N06443  1
C_U5_C9         0 U5_N38320  1n
X_U5_U13         U5_N35681 CLIMIT_HS BUF_BASIC_GEN PARAMS: VDD=1 VSS=0
+  VTHRESH=0.5
X_U5_U4         U5_N36255 DRVH_PRE U5_N35669 AND2_BASIC_GEN PARAMS: VDD=1 VSS=0
+  VTHRESH=500E-3
C_U5_C8         0 U5_N35681  1n
R_U5_R9         U5_N38308 U5_N38320  4
E_U5_ABM6         U5_N500741 0 VALUE { IF(V(U5_CL_MASK) > 0.5, 2.5, 4.2)    }
C_U5_C2         0 U5_N06443  1n
R_U5_R8         U5_N35669 U5_N35681  25
E_U5_ABM1         U5_N06376 0 VALUE { (V(UVLO_OUT) * -200m)    }
X_U5_U14         U5_N38320 U5_N38308 d_d1
X_U5_U12         U5_N35681 U5_N35669 d_d1
C_U5_C6         0 U5_N49148  1n
X_U4         MIN_TOFF MIN_TOFF_N INV_BASIC_GEN PARAMS: VDD=1 VSS=0
+  VTHRESH=500E-3
R_U4_R2         U4_N15867 MODE_LOGIC  1
E_U4_ABM2         U4_N15867 0 VALUE { IF(V(MODE) > 0.8,1,0)    }
X_U4_S1    U4_N18546 0 EN 0 LogicTrans_U4_S1
X_U4_U1         EN_LOGIC U4_N18546 INV_BASIC_GEN PARAMS: VDD=1 VSS=0
+  VTHRESH=500E-3
V_U4_V1         U4_N228333 0 0.2
C_U4_C2         0 MODE_LOGIC  1n
V_U4_V2         U4_N23322 0 0.65
X_U4_U2         EN U4_N23322 U4_N228333 U4_N23028 COMPHYS_BASIC_GEN PARAMS:
+  VDD=1 VSS=0 VTHRESH=0.5
X_U4_U3         U4_N23028 EN_LOGIC BUF_DELAY_BASIC_GEN PARAMS: VDD=1 VSS=0
+  VTHRESH=0.5 DELAY={50u*(1-SS)}
X_U3         MIN_TON MIN_TON_N INV_BASIC_GEN PARAMS: VDD=1 VSS=0 VTHRESH=500E-3
X_U2_U9         U2_N14352 U2_N10820 MIN_TON COMP_BASIC_GEN PARAMS: VDD=1 VSS=0
+  VTHRESH=0.5
R_U2_R2         U2_N41374 U2_N14352  930k
C_U2_C2         0 U2_N10820  2.32p
R_U2_R3         U2_N10820 VIN  630k
X_U2_U11         DRVH_PRE U2_N12733 INV_BASIC_GEN PARAMS: VDD=1 VSS=0
+  VTHRESH=500E-3
E_U2_E1         U2_N41374 0 SWBY4 0 1
X_U2_S1    U2_N12733 0 U2_N10820 0 Minton_U2_S1
C_U2_C3         0 U2_N14352  5p
E_GAIN1         N73876 0 VALUE {1 * V(HS_ON)}
V_V1         MODE 0 0Vdc
X_U8_U16         U8_N96933 MIN_TON_N U8_N109134 AND2_BASIC_GEN PARAMS: VDD=1
+  VSS=0 VTHRESH=500E-3
X_U8_U27         U8_N123495 U8_N97725 N127397 U8_N129154 srlatchrhp_basic_gen
+  PARAMS: VDD=1 VSS=0 VTHRESH=0.5
X_U8_U9         U8_PWM U8_N96933 INV_BASIC_GEN PARAMS: VDD=1 VSS=0
+  VTHRESH=500E-3
X_U8_U20         LS_ON U8_LS_ON_N INV_BASIC_GEN PARAMS: VDD=1 VSS=0
+  VTHRESH=500E-3
X_U8_U799         U8_N109134 SDWN U8_N96973 OR2_BASIC_GEN PARAMS: VDD=1 VSS=0
+  VTHRESH=500E-3
X_U8_U797         U8_N97687 U8_N97707 SDWN_N U8_LDRV_PBIAS U8_LS_SET
+  AND4_BASIC_GEN PARAMS: VDD=1 VSS=0 VTHRESH=500E-3
X_U8_U23         CLIMIT_HS U8_N97725 CL_DET U8_N129006 srlatchrhp_basic_gen
+  PARAMS: VDD=1 VSS=0 VTHRESH=0.5
X_U8_U29         PWMIN U8_N129006 U8_N129154 U8_PWM AND3_BASIC_GEN PARAMS:
+  VDD=1 VSS=0 VTHRESH=500E-3
X_U8_U22         MIN_TOFF_N U8_PWM U8_N96977 AND2_BASIC_GEN PARAMS: VDD=1 VSS=0
+  VTHRESH=500E-3
X_U8_U800         DRVL_PRE U8_N125193 INV_DELAY_BASIC_GEN PARAMS: VDD=1 VSS=0
+  VTHRESH=0.5 DELAY=40n
R_U8_R1         U8_N96973 U8_HS_RST  800
X_U8_U28         U8_N125193 DRVL_PRE U8_N123495 AND2_BASIC_GEN PARAMS: VDD=1
+  VSS=0 VTHRESH=500E-3
X_U8_U798         CAPRIO SDWN U8_N96977 U8_LDRV_PBIASBAR U8_LS_RST
+  OR4_BASIC_GEN PARAMS: VDD=1 VSS=0 VTHRESH=500E-3
X_U8_U14         HS_ON U8_HS_ON_N INV_BASIC_GEN PARAMS: VDD=1 VSS=0
+  VTHRESH=500E-3
X_U8_U18         U8_LS_SET U8_LS_RST U8_N97631 U8_LS_ON_PRE
+  srlatchrhp_basic_gen PARAMS: VDD=1 VSS=0 VTHRESH=0.5
X_U8_U7         U8_LS_ON_PRE SDWN_N U8_PWM U8_HS_SET AND3_BASIC_GEN PARAMS:
+  VDD=1 VSS=0 VTHRESH=500E-3
X_U8_U795         PWMIN SDWN U8_LDRV_PBIAS U8_LDRV_PBIASBAR
+  srlatchrhp_basic_gen PARAMS: VDD=1 VSS=0 VTHRESH=0.5
C_U8_C1         0 U8_HS_RST  10p
X_U8_U25         CLIMIT_LS SDWN U8_N97725 OR2_BASIC_GEN PARAMS: VDD=1 VSS=0
+  VTHRESH=500E-3
X_U8_U8         U8_HS_SET U8_HS_RST HS_ON N96925 srlatchrhp_basic_gen PARAMS:
+  VDD=1 VSS=0 VTHRESH=0.5
X_U8_U12         U8_N96973 U8_HS_RST d_d1
X_U8_U13         U8_HS_ON_N U8_N96933 U8_N97687 AND2_BASIC_GEN PARAMS: VDD=1
+  VSS=0 VTHRESH=500E-3
X_U8_U15         U8_HS_ON_N U8_N97631 LS_ON AND2_BASIC_GEN PARAMS: VDD=1 VSS=0
+  VTHRESH=500E-3
X_U8_U10         CAPRIO U8_N97707 INV_BASIC_GEN PARAMS: VDD=1 VSS=0
+  VTHRESH=500E-3
R_R4         0 EN  160MEG
X_U26         N73924 P100 BUF_BASIC_GEN PARAMS: VDD=1 VSS=0 VTHRESH=0.5
V_V2         N184131 0 7.4
C_U7_C2         0 U7_N14955265  1n
V_U7_V1         U7_N14956521 SW 545m
R_U7_R1         0 ISENSE_HS  1k
X_U7_U12         DRVL_PRE EN_LOGIC U7_N14955685 AND2_BASIC_GEN PARAMS: VDD=1
+  VSS=0 VTHRESH=500E-3
X_U7_U7         U7_N14955383 U7_N14955265 U7_N14955877 U7_PMOS_CTRL
+  MUX2_BASIC_GEN PARAMS: VDD=1 VSS=0 VTHRESH=0.5
R_U7_R5         U7_N14956411 U7_N14955667  1
X_U7_U14         LS_ON UVLO_OUT U7_N14955245 DRVL_PRE AND3_BASIC_GEN PARAMS:
+  VDD=1 VSS=0 VTHRESH=500E-3
E_U7_ABM2         U7_N14955959 0 VALUE { 1m*((-302.17/(V(VIN) + 0.88))+912.92)
+    }
X_U7_U5         U7_N14955277 U7_N14956521 d_d1special
C_U7_C3         0 U7_N14955667  1n
X_U7_U1         HS_ON U7_N14956025 BUF_DELAY_BASIC_GEN PARAMS: VDD=1 VSS=0
+  VTHRESH=0.5 DELAY=2n
X_U7_U13         HS_ON UVLO_OUT U7_N14956025 DRVH_PRE AND3_BASIC_GEN PARAMS:
+  VDD=1 VSS=0 VTHRESH=500E-3
X_U7_S1    U7_PMOS_CTRL 0 U7_N14955161 SW Driver_U7_S1
X_U7_H2    U7_N14955277 GND 0 ISENSE_LS Driver_U7_H2
X_U7_U4         LS_ON U7_N14955245 BUF_DELAY_BASIC_GEN PARAMS: VDD=1 VSS=0
+  VTHRESH=0.5 DELAY=2n
X_U7_S2    U7_NMOS_CTRL 0 SW U7_N14955277 Driver_U7_S2
E_U7_ABM3         U7_N14956411 0 VALUE { 1m*((-219.375/(V(VIN) + 0.5))+858.75)
+    }
R_U7_R4         U7_N14955959 U7_N14955265  1
V_U7_V2         SW U7_N14956579 545m
X_U7_H1    VIN U7_N14955161 ISENSE_HS 0 Driver_U7_H1
R_U7_R2         0 ISENSE_LS  1k
X_U7_U10         EN_LOGIC DRVH_PRE U7_N14955877 AND2_BASIC_GEN PARAMS: VDD=1
+  VSS=0 VTHRESH=500E-3
X_U7_U8         0 U7_N14955667 U7_N14955685 U7_NMOS_CTRL MUX2_BASIC_GEN PARAMS:
+  VDD=1 VSS=0 VTHRESH=0.5
X_U7_U6         U7_N14956579 U7_N14955161 d_d1special
E_U7_ABM4         U7_N14955383 0 VALUE { IF( V(0) >0.5,1,0)    }
L_L2         SW N303031  1u
E_U11_ABM2         U11_N2219611 0 VALUE { {LIMIT(V(U11_N248736), 0, 1.25)*0.64}
+     }
V_U11_V1         U11_N221204 0 4.8
R_U11_R10         U11_N2219611 U11_N222355  1
C_U11_C5         U11_N222355 0  1n IC={SS*0.8}
E_U11_ABM4         U11_N231653 0 VALUE { (1+ (V(0) *50m) +
+ (V(P100)*5m))*
+ V(U11_N222355)  }
R_U11_R9         U11_N220353 U11_N220347  1
E_U11_ABM1         U11_N220347 0 VALUE { IF(V(SDWN_N) < 0.5,0,1)    }
X_U11_S1    U11_N226363 0 SS_TR 0 SoftStart_U11_S1
X_U11_U9         SDWN_N U11_N226363 INV_BASIC_GEN PARAMS: VDD=1 VSS=0
+  VTHRESH=500E-3
C_U11_C4         0 U11_N220353  1n
R_U11_R11         U11_N231653 INT_VREF  1
X_U11_U8         SS_TR U11_N221204 d_d1
C_U11_C6         0 INT_VREF  1n
G_U11_ABMII1         U11_N221204 SS_TR VALUE { V(U11_N220353)*2.5u    }
C_U11_C7         0 SS_TR  5p
E_U11_ABM3         SS_END 0 VALUE { IF(V(U11_N222355)>0.795,1,0 )    }
E_U11_E1         U11_N248736 0 SS_TR GND 1
X_U6         SDWN_N SDWN INV_BASIC_GEN PARAMS: VDD=1 VSS=0 VTHRESH=500E-3
C_C5         0 IAVG  1n
E_U1_ABM4         U1_N273241 0 VALUE { LIMIT(((V(INT_VREF) -V(FB1))*5.3u),
+ 500n,-500n)   }
R_U1_R3         U1_N147079 SWI  643k
R_U1_R7         0 U1_N147163  6k
R_U1_R11         U1_INNER_REF 0  2.4G
X_U1_U2         U1_INNER_REF U1_INNER_FB U1_N264687 COMP_BASIC_GEN PARAMS:
+  VDD=1 VSS=0 VTHRESH=0.5
X_U1_U3         FB1 U1_N147219 U1_N147271 COMP_BASIC_GEN PARAMS: VDD=1 VSS=0
+  VTHRESH=0.5
E_U1_ABM10         U1_INNER_REF_CLAMP 0 VALUE { MIN(V(VIN),5)    }
X_U1_U8         PAUSE P100 U1_FBREF_SHORT OR2_BASIC_GEN PARAMS: VDD=1 VSS=0
+  VTHRESH=500E-3
X_U1_S3    SDWN_N 0 U1_INNER_FB U1_INNER_REF ErrorAmp_U1_S3
V_U1_V6         U1_N194447 0 0.744
X_U1_U11         U1_N264687 U1_N265822 PAUSE PWMIN MUX2_BASIC_GEN PARAMS: VDD=1
+  VSS=0 VTHRESH=0.5
E_U1_E1         U1_N356524 0 U1_N147079 0 1
R_U1_R20         0 U1_N265822  50
R_U1_R15         U1_N148765 U1_N195543  1
V_U1_V2         U1_N147219 0 0.76
X_U1_U10         FB1 U1_N194447 U1_N194443 COMP_BASIC_GEN PARAMS: VDD=1 VSS=0
+  VTHRESH=0.5
T_U1_T1         U1_N264687 0 U1_N265822 0 Z0=50 TD=10n
R_U1_R12         U1_N147133 U1_N148771  1
R_U1_R6         U1_INNER_REF U1_ISINK  750k
G_U1_ABM3I1         0 U1_INNER_REF VALUE { IF((V(SDWN_N) < 0.5) |
+ (V(CL_DET) > 0.5),0,
+ V(U1_N148405))  }
X_U1_U6         U1_INNER_REF U1_INNER_REF_CLAMP d_d1
E_U1_ABM17         U1_N3532001 0 VALUE {
+  IF(V(HS_ON)>.5,((1.5188E-07*V(VOSI)**3-1.0433E-06*V(VOSI)**2+
+ 1.5384E-06*V(VOSI)-6.5813E-07)*V(IAVG)**5+(-1.3731E-06*
+ V(VOSI)**3+9.4097E-06*V(VOSI)**2-1.3761E-05*V(VOSI)+5.7787E-06)
+ *V(IAVG)**4+(4.6812E-06*V(VOSI)**3-3.2005E-05*V(VOSI)**2+
+ 4.6431E-05*V(VOSI)-1.9149E-05)*V(IAVG)**3+(-7.4285E-06*V(VOSI)**3
+ +5.0698E-05*V(VOSI)**2-7.3100E-05*V(VOSI)+2.9753E-05)*V(IAVG)**2+
+ (5.3971E-06*V(VOSI)**3-3.6817E-05*V(VOSI)**2+5.3023E-05*V(VOSI)
+ -2.1717E-05)*V(IAVG)+(-1.4411E-06*V(VOSI)**3+9.8649E-06*V(VOSI)**2
+-1.3759E-05*V(VOSI)+7.9460E-06))-.475u,0) }
C_U1_C9         0 U1_N148765  1n
V_U1_V1         U1_N147365 0 45m
R_U1_R8         SWBY4 U1_N147079  793k
R_U1_R19         U1_N3532001 U1_VCTRLM_LOOP  1
C_U1_C1         VOSI U1_INNER_FB  20p
X_U1_U5         SDWN_N U1_N147377 INV_BASIC_GEN PARAMS: VDD=1 VSS=0
+  VTHRESH=500E-3
X_U1_U1         U1_N147277 U1_N147365 d_d1
C_U1_C10         0 U1_VCTRLM_LOOP  1n
X_U1_U4         U1_N147271 U1_N147377 N148783 U1_SOFTSTART srlatchrhp_basic_gen
+  PARAMS: VDD=1 VSS=0 VTHRESH=0.5
R_U1_R17         0 SWBY4  476k
E_U1_ABM8         U1_N195543 0 VALUE { IF(V(U1_N194443) > 0.5,V(U1_VCLAMP),
+ 125n)   }
X_U1_S1    U1_FBREF_SHORT 0 U1_INNER_FB U1_ISINK ErrorAmp_U1_S1
R_U1_R1         U1_INNER_FB U1_N356524  1.288Meg
C_U1_C6         0 U1_N148771  1n
R_U1_R13         U1_VCLAMP U1_N273241  1
C_U1_C3         U1_N147163 U1_INNER_REF  10p
G_U1_ABMII3         U1_ISINK 0 VALUE { IF(V(CL_DET) > 0.5,125n,0)    }
X_U1_U9         0 U1_INNER_REF d_d1
X_U1_U7         U1_N148765 U1_N148771 U1_SOFTSTART U1_N148405 MUX2_BASIC_GEN
+  PARAMS: VDD=1 VSS=0 VTHRESH=0.5
C_U1_C7         0 U1_VCLAMP  1n
E_U1_ABM3         U1_N147133 0 VALUE { IF(V(U1_VCLAMP) > 125n, 125n,
+ IF (V(U1_VCLAMP) <-125n,
+ -125n,V(U1_VCLAMP)))  }
X_U1_S2    HS_ON 0 U1_N147277 U1_N147163 ErrorAmp_U1_S2
G_U1_ABMII4         U1_N147365 U1_N147277 VALUE { V(U1_VCTRLM)    }
E_U1_ABM18         U1_VCTRLM 0 VALUE { IF(V(SS_END)>0.5,
+  V(U1_VCTRLM_LOOP),1.5u)    }
X_U20         VOS N184131 d_d1
C_C4         FB1 VOS  25p
R_R6         N303031 VOS  10.8m
R_R16         GND PAD  1m
R_R3         N73876 N73924  200k
E_ABM2         N2792911 0 VALUE { {{IF(V(DRVH_PRE) >
+  0.5,V(ISENSE_HS),V(ISENSE_LS))
+ }
+ }  }
C_C2         0 N73924  1n
R_U10_R3         U10_N222172 U10_N14135  1
R_U10_R1         U10_N14627 U10_N00497  14.4k
E_U10_ABM6         U10_N2217831 0 VALUE { (V(INT_VREF)*-0.05*
+ +V(U10_OUT2))   }
X_U10_U5         FB1 U10_N14135 U10_N14627 COMP_BASIC_GEN PARAMS: VDD=1 VSS=0
+  VTHRESH=0.5
E_U10_ABM7         U10_N222172 0 VALUE { (V(U10_N221839)+
+ +V(U10_N222445))   }
R_U10_R6         U10_N2217831 U10_N221839  1
C_U10_C6         0 U10_N221839  1n
R_U10_R4         U10_N2192031 U10_N222445  1
C_U10_C3         0 U10_N14135  1n
E_U10_ABM4         U10_N2192031 0 VALUE { MAX(V(INT_VREF)*0.95,0.76)    }
C_U10_C4         0 U10_N222445  1n
X_U10_S1    U10_N226424 0 PG GND PG_SGND_U10_S1
X_U10_U9         U10_N00497 U10_OUT2 BUF_BASIC_GEN PARAMS: VDD=1 VSS=0
+  VTHRESH=0.5
C_U10_C1         0 U10_N00497  1n
X_U10_U10         U10_N00497 EN_LOGIC UVLO_OUT U10_N226424 NAND3_BASIC_GEN
+  PARAMS: VDD=1 VSS=0 VTHRESH=500E-3
X_U19         N73924 N73876 d_d1
E_E2         VOSI 0 VOS GND 1
E_E3         SWI 0 SW GND 1
E_E1         FB1 0 FB GND 1
R_R18         VOS VOUT_1  1u
R_R19         VOS VOUT_0  1u
.ENDS TPS82130_TRANS
*$
.subckt Mintoff_U3_S1 1 2 3 4
S_U3_S1         3 4 1 2 _U3_S1
RS_U3_S1         1 2 1G
.MODEL         _U3_S1 VSWITCH Roff=10e6 Ron=1.0 Voff=0.2 Von=0.8
.ends Mintoff_U3_S1
*$
.subckt LogicTrans_U4_S1 1 2 3 4
S_U4_S1         3 4 1 2 _U4_S1
RS_U4_S1         1 2 1G
.MODEL         _U4_S1 VSWITCH Roff=100e6 Ron=400k Voff=0.2 Von=0.8
.ends LogicTrans_U4_S1
*$
.subckt Minton_U2_S1 1 2 3 4
S_U2_S1         3 4 1 2 _U2_S1
RS_U2_S1         1 2 1G
.MODEL         _U2_S1 VSWITCH Roff=100e6 Ron=1 Voff=0.2 Von=0.8
.ends Minton_U2_S1
*$
.subckt Driver_U7_S1 1 2 3 4
S_U7_S1         3 4 1 2 _U7_S1
RS_U7_S1         1 2 1G
.MODEL         _U7_S1 VSWITCH Roff=10e6 Ron=115m Voff=0.4 Von=0.6
.ends Driver_U7_S1
*$
.subckt Driver_U7_H2 1 2 3 4
H_U7_H2         3 4 VH_U7_H2 1
VH_U7_H2         1 2 0V
.ends Driver_U7_H2
*$
.subckt Driver_U7_S2 1 2 3 4
S_U7_S2         3 4 1 2 _U7_S2
RS_U7_S2         1 2 1G
.MODEL         _U7_S2 VSWITCH Roff=10e6 Ron=52m Voff=0.4 Von=0.6
.ends Driver_U7_S2
*$
.subckt Driver_U7_H1 1 2 3 4
H_U7_H1         3 4 VH_U7_H1 1
VH_U7_H1         1 2 0V
.ends Driver_U7_H1
*$
.subckt SoftStart_U11_S1 1 2 3 4
S_U11_S1         3 4 1 2 _U11_S1
RS_U11_S1         1 2 1G
.MODEL         _U11_S1 VSWITCH Roff=1e9 Ron=2.8k Voff=0.2 Von=0.8
.ends SoftStart_U11_S1
*$
.subckt ErrorAmp_U1_S3 1 2 3 4
S_U1_S3         3 4 1 2 _U1_S3
RS_U1_S3         1 2 1G
.model _U1_S3 VSWITCH (roff={max(10G,1)} ron={min(10G,1)} voff={if(10G>1,0.9V,0.2V)} von={if(10G>1,0.2V,0.9V)})
.ends ErrorAmp_U1_S3
*$
.subckt ErrorAmp_U1_S1 1 2 3 4
S_U1_S1         3 4 1 2 _U1_S1
RS_U1_S1         1 2 1G
.MODEL         _U1_S1 VSWITCH Roff=1000e6 Ron=1 Voff=0.4V Von=0.8V
.ends ErrorAmp_U1_S1
*$
.subckt ErrorAmp_U1_S2 1 2 3 4
S_U1_S2         3 4 1 2 _U1_S2
RS_U1_S2         1 2 1G
.MODEL         _U1_S2 VSWITCH Roff=100e6 Ron=1m Voff=0.4V Von=0.8V
.ends ErrorAmp_U1_S2
*$
.subckt PG_SGND_U10_S1 1 2 3 4
S_U10_S1         3 4 1 2 _U10_S1
RS_U10_S1         1 2 1G
.MODEL         _U10_S1 VSWITCH Roff=30e6 Ron=150 Voff=0.2V Von=0.8
.ends PG_SGND_U10_S1
*$
.subckt d_d1 1 2
d1 1 2 dd1
.model dd1 d
+ is=1e-15
+ tt=1e-11
+ rs=0.005
+ n=0.001
.ends d_d1
*$
.subckt srlatchrhp_basic_gen s r q qb params: vdd=1 vss=0 vthresh=0.5
gq 0 qint value = {if(v(r) > {vthresh},-5,if(v(s)>{vthresh},5, 0))}
cqint qint 0 1n
rqint qint 0 1000meg
d_d10 qint my5 d_d1
v1 my5 0 {vdd}
d_d11 myvss qint d_d1
v2 myvss 0 {vss}
eq qqq 0 qint 0 1
x3 qqq qqqd1 buf_basic_gen params: vdd={vdd} vss={vss} vthresh={vthresh}
rqq qqqd1 q 1
eqb qbr 0 value = {if( v(q) > {vthresh}, {vss},{vdd})}
rqb qbr qb 1
cdummy1 q 0 1n
cdummy2 qb 0 1n
.ic v(qint) {vss}
.model d_d1 d
+ is=1e-15
+ tt=1e-11
+ rs=0.005
+ n=0.01
.ends srlatchrhp_basic_gen
*$
.subckt d_d1special 1 2
d1 1 2 dd1spec
.model dd1spec d
+ is=1e-15
+ tt=1e-11
+ rs=0.8
+ n=0.01
.ends d_d1special
*$
.SUBCKT INV_BASIC_GEN A  Y PARAMS: VDD=1 VSS=0 VTHRESH=0.5
E_ABMGATE    YINT 0 VALUE {{IF(V(A) > {VTHRESH} ,
+ {VSS},{VDD})}}
RINT YINT Y 1
CINT Y 0 1n
.ENDS INV_BASIC_GEN
*$
.SUBCKT COMP_BASIC_GEN INP INM Y PARAMS: VDD=1 VSS=0 VTHRESH=0.5
E_ABM Yint 0 VALUE {IF (V(INP) >
+ V(INM), {VDD},{VSS})}
R1 Yint Y 1
C1 Y 0 1n
.ENDS COMP_BASIC_GEN
*$
.SUBCKT COMPHYS_BASIC_GEN INP INM HYS OUT PARAMS: VDD=5 VSS=0 VTHRESH=2.5
EIN INP1 INM1 INP INM 1
EHYS INP1 INP2 VALUE { IF( V(1) > {VTHRESH},-V(HYS),0) }
EOUT OUT 0 VALUE { IF( V(INP2)>V(INM1), {VDD} ,{VSS}) }
R1 OUT 1 1
C1 1 0 5n
RINP1 INP1 0 1K
.ENDS COMPHYS_BASIC_GEN
*$
.SUBCKT COMPHYS2_BASIC_GEN INP INM HYS OUT PARAMS: VDD=5 VSS=0 VTHRESH=2.5
+ T=10
EIN INP1 INM1 INP INM 1
EHYS INM2 INM1 VALUE { IF( V(1) > {VTHRESH},-V(HYS)/2,V(HYS)/2) }
EOUT OUT 0 VALUE { IF( V(INP1)>V(INM2), {VDD} ,{VSS}) }
R1 OUT 1 1
C1 1 0 {T*1e-9}
RINP1 INP1 0 10K
RINM2 INM2 0 10K
.ENDS COMPHYS2_BASIC_GEN
*$
.SUBCKT ONE_SHOT IN OUT
+ PARAMs:  T=100
S_S1         MEAS 0 RESET2 0 S1
E_ABM1         CH 0 VALUE { if( V(IN)>0.5 | V(OUT)>0.5,1,0)    }
R_R2         RESET2 RESET  0.1
E_ABM3         OUT 0 VALUE { if( V(MEAS)<0.5 & V(CH)>0.5,1,0)    }
R_R1         MEAS CH  {T}
C_C2         0 RESET2  1.4427n
C_C1         0 MEAS  1.4427n
E_ABM2         RESET 0 VALUE { if(V(CH)<0.5,1,0)    }
.MODEL         S1 VSWITCH Roff=1e9 Ron=1.0 Voff=0.25V Von=0.75V
.ENDS ONE_SHOT
*$
.SUBCKT AND2_BASIC_GEN A B Y PARAMS: VDD=1 VSS=0 VTHRESH=0.5
E_ABMGATE    YINT 0 VALUE {{IF(V(A) > {VTHRESH}  &
+ V(B) > {VTHRESH},{VDD},{VSS})}}
RINT YINT Y 1
CINT Y 0 1n
.ENDS AND2_BASIC_GEN
*$
.SUBCKT AND3_BASIC_GEN A B C Y PARAMS: VDD=1 VSS=0 VTHRESH=0.5
E_ABMGATE    YINT 0 VALUE {{IF(V(A) > {VTHRESH}  &
+ V(B) > {VTHRESH} &
+ V(C) > {VTHRESH},{VDD},{VSS})}}
RINT YINT Y 1
CINT Y 0 1n
.ENDS AND3_BASIC_GEN
*$
.SUBCKT AND4_BASIC_GEN A B C D Y PARAMS: VDD=1 VSS=0 VTHRESH=0.5
E_ABMGATE    YINT 0 VALUE {{IF(V(A) > {VTHRESH}  &
+ V(B) > {VTHRESH} &
+ V(C) > {VTHRESH} &
+ V(D) > {VTHRESH},{VDD},{VSS})}}
RINT YINT Y 1
CINT Y 0 1n
.ENDS AND4_BASIC_GEN
*$
.SUBCKT NAND2_BASIC_GEN A B Y PARAMS: VDD=1 VSS=0 VTHRESH=0.5
E_ABMGATE    YINT 0 VALUE {{IF(V(A) > {VTHRESH}  &
+ V(B) > {VTHRESH},{VSS},{VDD})}}
RINT YINT Y 1
CINT Y 0 1n
.ENDS NAND2_BASIC_GEN
*$
.SUBCKT NAND3_BASIC_GEN A B C Y PARAMS: VDD=1 VSS=0 VTHRESH=0.5
E_ABMGATE    YINT 0 VALUE {{IF(V(A) > {VTHRESH}  &
+ V(B) > {VTHRESH} &
+ V(C) > {VTHRESH},{VSS},{VDD})}}
RINT YINT Y 1
CINT Y 0 1n
.ENDS NAND3_BASIC_GEN
*$
.SUBCKT NAND4_BASIC_GEN A B C D Y PARAMS: VDD=1 VSS=0 VTHRESH=0.5
E_ABMGATE    YINT 0 VALUE {{IF(V(A) > {VTHRESH}  &
+ V(B) > {VTHRESH} &
+ V(C) > {VTHRESH} &
+ V(D) > {VTHRESH},{VSS},{VDD})}}
RINT YINT Y 1
CINT Y 0 1n
.ENDS NAND4_BASIC_GEN
*$
.SUBCKT OR2_BASIC_GEN A B Y PARAMS: VDD=1 VSS=0 VTHRESH=0.5
E_ABMGATE    YINT 0 VALUE {{IF(V(A) > {VTHRESH}  |
+ V(B) > {VTHRESH},{VDD},{VSS})}}
RINT YINT Y 1
CINT Y 0 1n
.ENDS OR2_BASIC_GEN
*$
.SUBCKT OR3_BASIC_GEN A B C Y PARAMS: VDD=1 VSS=0 VTHRESH=0.5
E_ABMGATE    YINT 0 VALUE {{IF(V(A) > {VTHRESH}  |
+ V(B) > {VTHRESH} |
+ V(C) > {VTHRESH},{VDD},{VSS})}}
RINT YINT Y 1
CINT Y 0 1n
.ENDS OR3_BASIC_GEN
*$
.SUBCKT OR4_BASIC_GEN A B C D Y PARAMS: VDD=1 VSS=0 VTHRESH=0.5
E_ABMGATE    YINT 0 VALUE {{IF(V(A) > {VTHRESH}  |
+ V(B) > {VTHRESH} |
+ V(C) > {VTHRESH} |
+ V(D) > {VTHRESH},{VDD},{VSS})}}
RINT YINT Y 1
CINT Y 0 1n
.ENDS OR4_BASIC_GEN
*$
.SUBCKT NOR2_BASIC_GEN A B Y PARAMS: VDD=1 VSS=0 VTHRESH=0.5
E_ABMGATE    YINT 0 VALUE {{IF(V(A) > {VTHRESH}  |
+ V(B) > {VTHRESH},{VSS},{VDD})}}
RINT YINT Y 1
CINT Y 0 1n
.ENDS NOR2_BASIC_GEN
*$
.SUBCKT NOR3_BASIC_GEN A B C Y PARAMS: VDD=1 VSS=0 VTHRESH=0.5
E_ABMGATE    YINT 0 VALUE {{IF(V(A) > {VTHRESH}  |
+ V(B) > {VTHRESH} |
+ V(C) > {VTHRESH},{VSS},{VDD})}}
RINT YINT Y 1
CINT Y 0 1n
.ENDS NOR3_BASIC_GEN
*$
.SUBCKT NOR4_BASIC_GEN A B C D Y PARAMS: VDD=1 VSS=0 VTHRESH=0.5
E_ABMGATE    YINT 0 VALUE {{IF(V(A) > {VTHRESH}  |
+ V(B) > {VTHRESH} |
+ V(C) > {VTHRESH} |
+ V(D) > {VTHRESH},{VSS},{VDD})}}
RINT YINT Y 1
CINT Y 0 1n
.ENDS NOR4_BASIC_GEN
*$
.SUBCKT NOR5_BASIC_GEN A B C D E Y PARAMS: VDD=1 VSS=0 VTHRESH=0.5
E_ABMGATE YINT 0 VALUE {{IF(V(A) > {VTHRESH}  |
+ V(B) > {VTHRESH} |
+ V(C) > {VTHRESH} |
+ V(D) > {VTHRESH} |
+ V(E) > {VTHRESH},{VSS},{VDD})}}
RINT YINT Y 1
CINT Y 0 1n
.ENDS NOR5_BASIC_GEN
*$
.SUBCKT NOR6_BASIC_GEN A B C D E F Y PARAMS: VDD=1 VSS=0 VTHRESH=0.5
E_ABMGATE YINT 0 VALUE {{IF(V(A) > {VTHRESH}  |
+ V(B) > {VTHRESH} |
+ V(C) > {VTHRESH} |
+ V(D) > {VTHRESH} |
+ V(E) > {VTHRESH} |
+ V(F) > {VTHRESH},{VSS},{VDD})}}
RINT YINT Y 1
CINT Y 0 1n
.ENDS NOR6_BASIC_GEN
*$
.SUBCKT XOR2_BASIC_GEN A B Y PARAMS: VDD=1 VSS=0 VTHRESH=0.5
E_ABMGATE  YINT 0 VALUE {{IF(V(A) > {VTHRESH}  !=
+ V(B) > {VTHRESH},{VDD},{VSS})}}
RINT YINT Y 1
CINT Y 0 1n
.ENDS XOR2_BASIC_GEN
*$
.SUBCKT XNOR2_BASIC_GEN A B Y PARAMS: VDD=1 VSS=0 VTHRESH=0.5
E_ABMGATE  YINT 0 VALUE {{IF(V(A) > {VTHRESH}  !=
+ V(B) > {VTHRESH},{VSS},{VDD})}}
RINT YINT Y 1
CINT Y 0 1n
.ENDS XNOR2_BASIC_GEN
*$
.SUBCKT MUX2_BASIC_GEN A B S Y PARAMS: VDD=1 VSS=0 VTHRESH=0.5
E_ABMGATE  YINT 0 VALUE {{IF(V(S) > {VTHRESH},
+ V(B),V(A))}}
RINT YINT Y 1
CINT Y 0 1n
.ENDS MUX2_BASIC_GEN
*$
.SUBCKT INV_DELAY_BASIC_GEN A  Y PARAMS: VDD=1 VSS=0 VTHRESH=0.5 DELAY = 10n
E_ABMGATE1    YINT1 0 VALUE {{IF(V(A) > {VTHRESH} ,
+ {VDD},{VSS})}}
RINT YINT1 YINT2 1
CINT YINT2 0 {DELAY*1.3}
E_ABMGATE2    YINT3 0 VALUE {{IF(V(YINT2) > {VTHRESH} ,
+ {VSS},{VDD})}}
RINT2 YINT3 Y 1
CINT2 Y 0 1n
.ENDS INV_DELAY_BASIC_GEN
*$
.SUBCKT BUF_DELAY_BASIC_GEN A  Y PARAMS: VDD=1 VSS=0 VTHRESH=0.5 DELAY = 10n
E_ABMGATE1    YINT1 0 VALUE {{IF(V(A) > {VTHRESH} ,
+ {VDD},{VSS})}}
RINT YINT1 YINT2 1
CINT YINT2 0 {DELAY*1.44}
E_ABMGATE2    YINT3 0 VALUE {{IF(V(YINT2) > {VTHRESH} ,
+ {VDD},{VSS})}}
RINT2 YINT3 Y 1
CINT2 Y 0 1n
.ENDS BUF_DELAY_BASIC_GEN
*$
.SUBCKT BUF_BASIC_GEN A  Y PARAMS: VDD=1 VSS=0 VTHRESH=0.5
E_ABMGATE    YINT 0 VALUE {{IF(V(A) > {VTHRESH} ,
+ {VDD},{VSS})}}
RINT YINT Y 1
CINT Y 0 1n
.ENDS BUF_BASIC_GEN
*$
.SUBCKT CESR IN OUT
+ PARAMs:  C=100u ESR=0.01 X=2 IC=0
C	IN 1  {C*X} IC={IC}
RESR	1 OUT {ESR/X}
.ENDS CESR
*$
.SUBCKT LDCR IN OUT
+ PARAMs:  L=1u DCR=0.01 IC=0
L	IN 1  {L} IC={IC}
RDCR	1 OUT {DCR}
.ENDS LDCR
*$
Xentry EN PAD FB GND PG SS_TR VIN VOUT_0 VOUT_1 TPS82130_TRANS
.ENDS library_simulation_spice_subcircuit_1
.SUBCKT library_simulation_spice_subcircuit_2 EN FB GND_0 GND_1 PG VIN_0 VIN_1 VOUT PAD
*$
**TPS82084
*****************************************************************************
* (C) Copyright 2015 Texas Instruments Incorporated. All rights reserved.
*****************************************************************************
** This model is designed as an aid for customers of Texas Instruments.
** TI and its licensors and suppliers make no warranties, either expressed
** or implied, with respect to this model, including the warranties of
** merchantability or fitness for a particular purpose. The model is
** provided solely on an "as is" basis. The entire risk as to its quality
** and performance is with the customer
*****************************************************************************
*
* This model is subject to change without notice. Texas Instruments
* Incorporated is not responsible for updating this model.
*
*****************************************************************************
* Released by: WEBENCH Design Center, Texas Instruments Inc.
* Part: TPS82084
* Date: 16JUL2015
* Model Type: TRANSIENT
* Simulator: PSPICE
* Simulator Version: 16.2.0.p001
* EVM Order Number: TPS82084EVM-672
* EVM Users Guide: SLVUAC5A–December 2014–Revised April 2015
* Datasheet: SLVSD11 –JUNE 2015
* Model Version: Final 1.00
*
*****************************************************************************
*
* Updates:
* Final 1.00
* Release to Web
*
*
***************************************
.SUBCKT TPS82084_TRANS EN FB GND_0 GND_1 PG VIN_0 VIN_1 VOUT  PAD PARAMS: SS=1
Rin1 VIN_0 VIN  1m
Rin2 VIN_1 VIN  1m
Rgnd1 GND_0 GND 1m
Rgnd2 GND_1 GND 1m
vvout VOUT VOS 0
R_PWM_R2         PWM_N290478 PWM_LS_SET  1
X_PWM_U30         LV_DETECTED PWM_CAPRIO_Z PWM_NCV AND2_BASIC_GEN PARAMS: VDD=1
+  VSS=0 VTHRESH=500E-3
X_PWM_U28         PWM_N167763 DRVL_PRE PWM_N167705 AND2_BASIC_GEN PARAMS: VDD=1
+  VSS=0 VTHRESH=500E-3
X_PWM_U8         PWM_N251358 PWM_HS_RST HS_ON N167899 SRLATCHRHP_BASIC_GEN
+  PARAMS: VDD=1 VSS=0 VTHRESH=0.5
X_PWM_U797         PWM_N168069 PWM_CAPRIO_Z SDWN_N PWM_LDRV_PBIAS PWM_N290478
+  AND4_BASIC_GEN PARAMS: VDD=1 VSS=0 VTHRESH=500E-3
X_PWM_U33         PWM_NCV_Z PWM_N211078 PWM_HS_SET AND2_BASIC_GEN PARAMS: VDD=1
+  VSS=0 VTHRESH=500E-3
X_PWM_U801         MIN_TOFF_CL_N SDWN PWM_N167797 OR2_BASIC_GEN PARAMS: VDD=1
+  VSS=0 VTHRESH=500E-3
C_PWM_C2         0 PWM_LS_SET  1n
X_PWM_U12         PWM_N167835 PWM_HS_RST  d_d2 PARAMS:
C_PWM_C1         0 PWM_HS_RST  10p
X_PWM_U24         MIN_TOFF_CL_N PWM_MIN_TOFF_CL INV_BASIC_GEN PARAMS: VDD=1
+  VSS=0 VTHRESH=500E-3
X_PWM_U14         HS_ON PWM_HS_ON_N INV_BASIC_GEN PARAMS: VDD=1 VSS=0
+  VTHRESH=500E-3
R_PWM_R3         PWM_N290780 PWM_N168025  1
X_PWM_U29         PWMIN PWM_N167797 PWM_N167659 PWM_PWM AND3_BASIC_GEN PARAMS:
+  VDD=1 VSS=0 VTHRESH=500E-3
X_PWM_U19         LV_DETECTED PWM_LOW_VO_DETECT_Z INV_BASIC_GEN PARAMS: VDD=1
+  VSS=0 VTHRESH=500E-3
X_PWM_U26         PWM_N167907 MIN_TON_N MIN_TON_ABS_N PWM_N167839
+  AND3_BASIC_GEN PARAMS: VDD=1 VSS=0 VTHRESH=500E-3
X_PWM_U804         PWM_N167839 SDWN PWM_MIN_TOFF_CL PWM_N167835 OR3_BASIC_GEN
+  PARAMS: VDD=1 VSS=0 VTHRESH=500E-3
C_PWM_C3         0 PWM_N168025  1n
X_PWM_U798         CAPRIO SDWN PWM_N167635 PWM_LDRV_PBIASBAR PWM_DEFAULT_PATH_L
+  OR4_BASIC_GEN PARAMS: VDD=1 VSS=0 VTHRESH=500E-3
X_PWM_U795         PWMIN SDWN PWM_LDRV_PBIAS PWM_LDRV_PBIASBAR
+  SRLATCHRHP_BASIC_GEN PARAMS: VDD=1 VSS=0 VTHRESH=0.5
R_PWM_R4         PWM_HS_SET PWM_N251358  1
X_PWM_U21         PWM_NCV PWM_NCV_Z INV_BASIC_GEN PARAMS: VDD=1 VSS=0
+  VTHRESH=500E-3
X_PWM_U22         MIN_TOFF_N PWM_PWM PWM_N167635 AND2_BASIC_GEN PARAMS: VDD=1
+  VSS=0 VTHRESH=500E-3
X_PWM_U20         LS_ON PWM_LS_ON_N INV_BASIC_GEN PARAMS: VDD=1 VSS=0
+  VTHRESH=500E-3
R_PWM_R5         HS_ON HS_ON  1
X_PWM_U7         PWM_LS_ON_PRE SDWN_N PWM_PWM PWM_N211078 AND3_BASIC_GEN
+  PARAMS: VDD=1 VSS=0 VTHRESH=500E-3
X_PWM_U13         PWM_HS_ON_N PWM_N167907 PWM_N168069 AND2_BASIC_GEN PARAMS:
+  VDD=1 VSS=0 VTHRESH=500E-3
C_PWM_C4         0 PWM_N251358  1n
X_PWM_U15         PWM_HS_ON_N PWM_N168025 LS_ON AND2_BASIC_GEN PARAMS: VDD=1
+  VSS=0 VTHRESH=500E-3
C_PWM_C5         0 HS_ON  1n
X_PWM_U16         PWM_DEFAULT_PATH_L PWM_NCV_Z PWM_LS_RST AND2_BASIC_GEN
+  PARAMS: VDD=1 VSS=0 VTHRESH=500E-3
X_PWM_U27         PWM_N167705 PWM_N167797 N167801 PWM_N167659
+  SRLATCHRHP_BASIC_GEN PARAMS: VDD=1 VSS=0 VTHRESH=0.5
X_PWM_U9         PWM_PWM PWM_N167907 INV_BASIC_GEN PARAMS: VDD=1 VSS=0
+  VTHRESH=500E-3
X_PWM_U17         CAPRIO PWM_CAPRIO_Z INV_BASIC_GEN PARAMS: VDD=1 VSS=0
+  VTHRESH=500E-3
X_PWM_U18         PWM_LS_SET PWM_LS_RST PWM_N290780 PWM_LS_ON_PRE
+  SRLATCHRHP_BASIC_GEN PARAMS: VDD=1 VSS=0 VTHRESH=0.5
X_PWM_U800         DRVL_PRE PWM_N167763 INV_DELAY_BASIC_GEN PARAMS: VDD=1 VSS=0
+  VTHRESH=0.5 DELAY=40n
R_PWM_R1         PWM_N167835 PWM_HS_RST  800
X_U9         MIN_TON_ABS MIN_TON_ABS_N INV_BASIC_GEN PARAMS: VDD=1 VSS=0
+  VTHRESH=500E-3
X_H1    SW N14722982 IL 0 TPS62085_H1
X_U17         MIN_TOFF_CL MIN_TOFF_CL_N INV_BASIC_GEN PARAMS: VDD=1 VSS=0
+  VTHRESH=500E-3
X_U15         ABS_MIN_TOFF ABS_MIN_TOFF_N INV_BASIC_GEN PARAMS: VDD=1 VSS=0
+  VTHRESH=500E-3
X_U13_U4         U13_N33832 U13_N33808 BUF_DELAY_BASIC_GEN PARAMS: VDD=1 VSS=0
+  VTHRESH=0.5 DELAY=6n
R_U13_R2         U13_N16808550 VAVG  10k
X_U13_H1    PVIN U13_N16766543 ISENSE_HS 0 Driver_U13_H1
C_U13_C2         0 VAVG  1n
X_U13_D11         SW U13_N16766543  d_d2 PARAMS:
X_U13_S9    U13_DRVH_PRE_N 0 CN_INT 0 Driver_U13_S9
E_U13_E1         U13_N16808550 0 U13_N16808483 0 1
X_U13_U2         U13_N33760 U13_N33764 DRVH_PRE AND2_BASIC_GEN PARAMS: VDD=1
+  VSS=0 VTHRESH=500E-3
X_U13_S10    DRVH_PRE 0 PVIN CN_INT Driver_U13_S10
X_U13_S3    U13_DRVH 0 U13_N16766543 SW Driver_U13_S3
R_U13_R3         VOS U13_N16808483  1
X_U13_U11         HS_ON U13_N33760 BUF_DELAY_BASIC_GEN PARAMS: VDD=1 VSS=0
+  VTHRESH=0.5 DELAY=8n
X_U13_S6    U13_DRVL_PRE_N 0 U13_DRVL 0 Driver_U13_S6
X_U13_S2    DRVH_PRE 0 CP_INT U13_DRVH Driver_U13_S2
X_U13_U616         DRVL_PRE U13_DRVL_PRE_N INV_BASIC_GEN PARAMS: VDD=1 VSS=0
+  VTHRESH=500E-3
X_U13_U610         DRVH_PRE U13_DRVH_PRE_N INV_BASIC_GEN PARAMS: VDD=1 VSS=0
+  VTHRESH=500E-3
X_U13_H2    U13_N16766531 0 0 ISENSE_LS Driver_U13_H2
X_U13_D12         U13_N16766531 SW  d_d2 PARAMS:
X_U13_S7    DRVL_PRE 0 PVIN U13_DRVL Driver_U13_S7
C_U13_C3         0 U13_N16808483  1n
X_U13_U12         LS_ON U13_N33832 BUF_DELAY_BASIC_GEN PARAMS: VDD=1 VSS=0
+  VTHRESH=0.5 DELAY=8n
X_U13_S5    U13_DRVH_PRE_N 0 U13_DRVH 0 Driver_U13_S5
E_U13_ABM1         U13_N16808518 0 VALUE { IF(V(DRVH_PRE) >0.5 ,
+ V(ISENSE_HS),
+ V(ISENSE_LS) )  }
X_U13_S4    U13_DRVL 0 SW U13_N16766531 Driver_U13_S4
X_U13_U3         U13_N33832 U13_N33808 DRVL_PRE AND2_BASIC_GEN PARAMS: VDD=1
+  VSS=0 VTHRESH=500E-3
X_U13_S8    U13_DRVH_PRE_N 0 PVIN CP_INT Driver_U13_S8
R_U13_R1         U13_N16808518 IAVG  1k
X_U13_U1         U13_N33760 U13_N33764 BUF_DELAY_BASIC_GEN PARAMS: VDD=1 VSS=0
+  VTHRESH=0.5 DELAY=6n
C_U13_C1         0 IAVG  1n
R_Enable_R2         Enable_N06376 Enable_N06443  1
X_Enable_U10         HICCUP Enable_N56049 INV_BASIC_GEN PARAMS: VDD=1 VSS=0
+  VTHRESH=500E-3
E_Enable_ABM2         Enable_N522161 0 VALUE { (V(Enable_N06443) + 2.4)    }
C_Enable_C3         0 Enable_N03743  1n
R_Enable_R3         Enable_N522161 Enable_N03743  1
C_Enable_C2         0 Enable_N06443  1n
X_Enable_U11         Enable_N56049 UVLO_OUT EN_LOGIC Enable_N12192 SDWN_N
+  AND4_BASIC_GEN PARAMS: VDD=1 VSS=0 VTHRESH=500E-3
X_Enable_U5         VIN Enable_N03743 UVLO_OUT COMP_BASIC_GEN PARAMS: VDD=1
+  VSS=0 VTHRESH=0.5
E_Enable_ABM1         Enable_N06376 0 VALUE { (V(UVLO_OUT) * -200m)    }
V_Enable_V3         Enable_N12192 0
+PULSE {SS} 1 1u 10n 10n 1000 2000
X_U33         N14588914 N14589344 LV_DETECTED AND2_BASIC_GEN PARAMS: VDD=1
+  VSS=0 VTHRESH=500E-3
X_S11    N351522 0 VOS 0 TPS62085_S11
V_V1         MODE 0 0Vdc
R_R11         VIN VIN  1m
C_C2         0 N351938  1n
C_C5         CN_INT CP_INT  10n
V_V4         N365925 0 300m
X_U34         N14722982 N14723064 L_DERATED VARIIND
X_U2_U12         DRVH_PRE U2_N19880 INV_BASIC_GEN PARAMS: VDD=1 VSS=0
+  VTHRESH=500E-3
C_U2_C3         0 U2_N14352  5p
X_U2_U9         U2_N14352 U2_N10820 MIN_TON COMP_BASIC_GEN PARAMS: VDD=1 VSS=0
+  VTHRESH=0.5
X_U2_U13         U2_N19580 U2_N19824 MIN_TON_ABS COMP_BASIC_GEN PARAMS: VDD=1
+  VSS=0 VTHRESH=0.5
R_U2_R2         SWBY4 U2_N14352  1.925MEG
X_U2_S1    U2_N12733 0 U2_N10820 0 Minton_U2_S1
X_U2_S3    LV_DETECTED 0 U2_N21998 U2_N10820 Minton_U2_S3
C_U2_C4         0 U2_N19824  480p
C_U2_C2         0 U2_N10820  1.9p
V_U2_V4         U2_N19580 0 667m
X_U2_U10         U2_N19824 U2_N19572  d_d2 PARAMS:
R_U2_R1         U2_N21998 VIN  860k
X_U2_S2    U2_N19880 0 U2_N19824 0 Minton_U2_S2
V_U2_V5         U2_N19572 0 1.2
X_U2_U11         DRVH_PRE U2_N12733 INV_BASIC_GEN PARAMS: VDD=1 VSS=0
+  VTHRESH=500E-3
I_U2_I1         U2_N19572 U2_N19824 DC 6.4m
X_U19         N351938 N351928  d_d2 PARAMS:
X_U27         HICCUP SDWN N351522 OR2_BASIC_GEN PARAMS: VDD=1 VSS=0
+  VTHRESH=500E-3
R_R5         0 0  400k
X_U16         SS_NODE N14589344 INV_BASIC_GEN PARAMS: VDD=1 VSS=0
+  VTHRESH=500E-3
X_U18         N365925 VOS N14588914 COMP_BASIC_GEN PARAMS: VDD=1 VSS=0
+  VTHRESH=0.5
X_U26         N351938 P100 BUF_BASIC_GEN PARAMS: VDD=1 VSS=0 VTHRESH=0.5
X_U4_U3         FSW_LOGIC U4_N19391 INV_BASIC_GEN PARAMS: VDD=1 VSS=0
+  VTHRESH=500E-3
C_U4_C1         0 EN_LOGIC  1n
R_U4_R2         U4_N15867 MODE_LOGIC  1
R_U4_R1         U4_N15535 EN_LOGIC  1
C_U4_C4         0 FSW_LOGIC  1n
R_U4_R4         U4_N17314 FSW_LOGIC  1
E_U4_ABM2         U4_N15867 0 VALUE { IF(V(MODE) > 0.8,1,0)    }
E_U4_ABM4         U4_N17314 0 VALUE { IF(V(LV_DETECTED) > 0.895,1,0)    }
X_U4_S1    U4_N18546 0 EN 0 LogicTrans_U4_S1
C_U4_C2         0 MODE_LOGIC  1n
X_U4_U1         EN_LOGIC U4_N18546 INV_BASIC_GEN PARAMS: VDD=1 VSS=0
+  VTHRESH=500E-3
E_U4_ABM1         U4_N15535 0 VALUE { IF(V(EN) > 0.895,1,0)    }
X_U4_S3    U4_N19391 0 LV_DETECTED 0 LogicTrans_U4_S3
R_RDCR         N14723064 VOS  27m
X_Min_Toff_U9         Min_Toff_N16777542 Min_Toff_N16777534 ABS_MIN_TOFF
+  COMP_BASIC_GEN PARAMS: VDD=1 VSS=0 VTHRESH=0.5
V_Min_Toff_V4         Min_Toff_N16777542 0 667m
X_Min_Toff_U31         MIN_TOFF Min_Toff_VOUT_LOW_DETECTED_Z N16796980
+  AND2_BASIC_GEN PARAMS: VDD=1 VSS=0 VTHRESH=500E-3
X_Min_Toff_U24         LV_DETECTED Min_Toff_VOUT_LOW_DETECTED_Z INV_BASIC_GEN
+  PARAMS: VDD=1 VSS=0 VTHRESH=500E-3
C_Min_Toff_C2         0 Min_Toff_N16777534  480f
X_Min_Toff_U23         Min_Toff_N16777544 Min_Toff_TOFF_RS MIN_TOFF_CL
+  Min_Toff_N16777627 SRLATCHRHP_BASIC_GEN PARAMS: VDD=1 VSS=0 VTHRESH=0.5
I_Min_Toff_I1         Min_Toff_N16777530 Min_Toff_N16777534 DC 6.4u
X_Min_Toff_U22         CAPRIO Min_Toff_CAPRIO_Z INV_BASIC_GEN PARAMS: VDD=1
+  VSS=0 VTHRESH=500E-3
X_Min_Toff_U622         MIN_TOFF_CL ABS_MIN_TOFF MIN_TOFF OR2_BASIC_GEN PARAMS:
+  VDD=1 VSS=0 VTHRESH=500E-3
X_Min_Toff_U613         CLIMIT_HS Min_Toff_N16777544 Min_Toff_N16777587
+  MONOPOS_PS PARAMS: PW=20n
E_Min_Toff_ABM1         Min_Toff_N16777809 0 VALUE { IF(V(Min_Toff_N16777590) <
+  (V(VIN)/2) , 1, 0)    }
R_Min_Toff_R272         Min_Toff_N16777779 Min_Toff_N16777771  3.5
X_Min_Toff_S2    Min_Toff_N16777627 0 VIN Min_Toff_N16777590
+  Mintoff_Modified_Min_Toff_S2
C_Min_Toff_C172         0 Min_Toff_N16777771  1n
X_Min_Toff_U30         Min_Toff_VOUT_LOW_DETECTED_Z CAPRIO Min_Toff_NCV
+  AND2_BASIC_GEN PARAMS: VDD=1 VSS=0 VTHRESH=500E-3
C_Min_Toff_C3         Min_Toff_N16777590 VIN  600f
X_Min_Toff_U621         Min_Toff_N16777779 Min_Toff_N16777771 Min_Toff_TOFF_RS
+  OR2_BASIC_GEN PARAMS: VDD=1 VSS=0 VTHRESH=500E-3
X_Min_Toff_U21         Min_Toff_NCV Min_Toff_NCV_Z INV_BASIC_GEN PARAMS: VDD=1
+  VSS=0 VTHRESH=500E-3
R_Min_Toff_R7         0 Min_Toff_N16777587  1e8
R_Min_Toff_R1         Min_Toff_N16777809 Min_Toff_N16777779  1
G_Min_Toff_ABMI1         Min_Toff_N16777590 0 VALUE {  V(VOS)/210k    }
C_Min_Toff_C4         0 Min_Toff_N16777779  1n
V_Min_Toff_V5         Min_Toff_N16777530 0 1.2
X_Min_Toff_U623         Min_Toff_TOFF_RS Min_Toff_VOUT_LOW_DETECTED_Z N16785568
+  OR2_BASIC_GEN PARAMS: VDD=1 VSS=0 VTHRESH=500E-3
X_Min_Toff_U10         Min_Toff_N16777534 Min_Toff_N16777530  d_d2 PARAMS:
X_Min_Toff_U12         Min_Toff_N16777779 Min_Toff_N16777771  d_d2 PARAMS:
X_Min_Toff_S1    Min_Toff_N16777948 0 Min_Toff_N16777534 0
+  Mintoff_Modified_Min_Toff_S1
X_Min_Toff_U11         DRVL_PRE Min_Toff_N16777948 INV_BASIC_GEN PARAMS: VDD=1
+  VSS=0 VTHRESH=500E-3
C_C4         FB VOS  25p
E_GAIN1         N351928 0 VALUE {1 * V(HS_ON)}
V_ERROR_amp_V2         ERROR_amp_N360843 0 0.76
X_ERROR_amp_U1         ERROR_amp_N360871 ERROR_amp_N359583  d_d2 PARAMS:
T_ERROR_amp_T1         ERROR_amp_N361065 0 ERROR_amp_N361163 0 Z0=50 TD=300n
E_ERROR_amp_ABM4         ERROR_amp_N359573 0 VALUE { LIMIT(((V(INT_VREF)
+  -V(FB))*5.3u),
+ 500n,-500n)   }
X_ERROR_amp_U6         ERROR_amp_INNER_REF ERROR_amp_INNER_REF_CLAMP d_d2
+  PARAMS:
X_ERROR_amp_S3    SDWN_N 0 ERROR_amp_INNER_FB ERROR_amp_INNER_REF
+  ErrorAmp_ERROR_amp_S3
X_ERROR_amp_U9         0 ERROR_amp_INNER_REF  d_d2 PARAMS:
X_ERROR_amp_U11         ERROR_amp_N361065 ERROR_amp_N361163 PAUSE PWMIN
+  MUX2_BASIC_GEN PARAMS: VDD=1 VSS=0 VTHRESH=0.5
R_ERROR_amp_R13         ERROR_amp_VCLAMP ERROR_amp_N359573  2
R_ERROR_amp_R3         ERROR_amp_N360745 SW  644k
C_ERROR_amp_C9         0 ERROR_amp_N359595  1n
X_ERROR_amp_U12         LV_DETECTED ERROR_amp_N359525 ERROR_amp_FBREF_SHORT
+  OR2_BASIC_GEN PARAMS: VDD=1 VSS=0 VTHRESH=500E-3
X_ERROR_amp_U4         ERROR_amp_N360883 ERROR_amp_N360937 N361141 SS_NODE
+  SRLATCHRHP_BASIC_GEN PARAMS: VDD=1 VSS=0 VTHRESH=0.5
E_ERROR_amp_ABM8         ERROR_amp_N359551 0 VALUE { IF(V(ERROR_amp_N359501) >
+  0.5,V(ERROR_amp_VCLAMP),
+ 125n)   }
X_ERROR_amp_U5         SDWN_N ERROR_amp_N360937 INV_BASIC_GEN PARAMS: VDD=1
+  VSS=0 VTHRESH=500E-3
C_ERROR_amp_C3         ERROR_amp_N360815 ERROR_amp_INNER_REF  20p
V_ERROR_amp_V1         ERROR_amp_N359583 0 15m
R_ERROR_amp_R6         ERROR_amp_INNER_REF ERROR_amp_ISINK  743k
C_ERROR_amp_C6         0 ERROR_amp_N361129  1n
R_ERROR_amp_R11         ERROR_amp_INNER_REF 0  2.4G
X_ERROR_amp_S1    ERROR_amp_FBREF_SHORT 0 ERROR_amp_INNER_FB ERROR_amp_ISINK
+  ErrorAmp_ERROR_amp_S1
E_ERROR_amp_ABM10         ERROR_amp_INNER_REF_CLAMP 0 VALUE { MIN(V(VIN),5)
+  }
R_ERROR_amp_R15         ERROR_amp_N359595 ERROR_amp_N359551  1
R_ERROR_amp_R1         ERROR_amp_INNER_FB ERROR_amp_N360745  1.29MEG
R_ERROR_amp_R21         ERROR_amp_N361475 ERROR_amp_VCTRLM_NEW  1
V_ERROR_amp_V6         ERROR_amp_N359505 0 0.744
R_ERROR_amp_R17         0 SWBY4  476k
G_ERROR_amp_ABMII3         ERROR_amp_ISINK 0 VALUE { IF(V(MIN_TOFF_CL) >
+  0.5,125n,0)    }
X_ERROR_amp_U3         FB ERROR_amp_N360843 ERROR_amp_N360883 COMP_BASIC_GEN
+  PARAMS: VDD=1 VSS=0 VTHRESH=0.5
R_ERROR_amp_R22         VIN ERROR_amp_N393735  1
E_ERROR_amp_ABM7         ERROR_amp_N361475 0 VALUE { IF(V(ERROR_amp_N393735) >
+  4.2, (( 1.87525777E-02*V(VAVG)**4 - 2.20315321E-01*V(VAVG)**3 +
+  9.73431332E-01*V(VAVG)**2 - 1.85835591E-00*V(VAVG) +
+  2.38622011E-00)*V(IAVG)**6 + (-2.42326463E-01*V(VAVG)**4 +
+  2.88433195E-00*V(VAVG)**3 - 1.24787556E+01*V(VAVG)**2 + 2.24688188E+01*V(VAVG)
+  - 2.66302826E+01)*V(IAVG)**5 + ( 1.23832222E-00*V(VAVG)**4 -
+  1.49096354E+01*V(VAVG)**3 + 6.32648562E+01*V(VAVG)**2 - 1.07430368E+02*V(VAVG)
+  + 1.17442809E+02)*V(IAVG)**4 + (-3.15815548E-00*V(VAVG)**4 +
+  3.84343302E+01*V(VAVG)**3 - 1.59944993E+02*V(VAVG)**2 + 2.54791827E+02*V(VAVG)
+  - 2.56839905E+02)*V(IAVG)**3 +
+ ( 4.21141863E-00*V(VAVG)**4 - 5.18109401E+01*V(VAVG)**3 +
+  2.11099663E+02*V(VAVG)**2 - 3.11510517E+02*V(VAVG) +
+  2.87326481E+02)*V(IAVG)**2 + (-2.82214040E-00*V(VAVG)**4 +
+  3.51128583E+01*V(VAVG)**3 - 1.39863141E+02*V(VAVG)**2 + 1.88335884E+02*V(VAVG)
+  - 1.54282979E+02)*V(IAVG) + ( 8.55038148E-01*V(VAVG)**4 -
+  1.07290366E+01*V(VAVG)**3 + 4.18267263E+01*V(VAVG)**2 - 5.13102436E+01*V(VAVG)
+  + 3.74070366E+01)),
+ IF(V(ERROR_amp_N393735)>3.3,((-5.95742879E-01*V(VAVG)**2 +
+  2.15290779E-00*V(VAVG) - 1.23308259E-00)*V(IAVG)**6 + (
+  6.74408456E-00*V(VAVG)**2 - 2.45596253E+01*V(VAVG) +
+  1.46144202E+01)*V(IAVG)**5 + (-3.04809609E+01*V(VAVG)**2 +
+  1.11878716E+02*V(VAVG) - 6.91078921E+01)*V(IAVG)**4 + (
+  6.97314481E+01*V(VAVG)**2 - 2.57918605E+02*V(VAVG) +
+  1.64936127E+02)*V(IAVG)**3 +  (-8.38318504E+01*V(VAVG)**2 +
+  3.12116385E+02*V(VAVG) - 2.05301492E+02)*V(IAVG)**2 + (
+  4.91682419E+01*V(VAVG)**2 - 1.83863832E+02*V(VAVG) + 1.23111866E+02)*V(IAVG) +
+  (-1.18276918E+01*V(VAVG)**2 + 4.43711017E+01*V(VAVG) - 2.74731621E+01)),
+ (( 2.35063531E-03*V(VAVG) + 7.01241595E-02)*V(IAVG)**6 + (
+  1.26530954E-01*V(VAVG) - 1.11726427E-00)*V(IAVG)**5 + (-1.29454099E-00*V(VAVG)
+  + 6.56158165E-00)*V(IAVG)**4 +( 4.47455670E-00*V(VAVG) -
+  1.81521918E+01)*V(IAVG)**3 +(-7.00163936E-00*V(VAVG) +
+  2.50029059E+01)*V(IAVG)**2 + ( 5.49651495E-00*V(VAVG) -
+  1.69007772E+01)*V(IAVG) + (-2.38749773E-00*V(VAVG) + 7.56586665E-00)))) }
C_ERROR_amp_C7         0 ERROR_amp_VCLAMP  1n
E_ERROR_amp_ABM3         ERROR_amp_N360787 0 VALUE { IF(V(ERROR_amp_VCLAMP) >
+  125n, 125n,
+ IF (V(ERROR_amp_VCLAMP) <-125n,
+ -125n,V(ERROR_amp_VCLAMP)))  }
C_ERROR_amp_C12         0 ERROR_amp_N393735  1n
G_ERROR_amp_ABM3I1         0 ERROR_amp_INNER_REF VALUE { IF((V(SDWN_N) < 0.5) |
+
+ (V(MIN_TOFF_CL) > 0.5),0,
+ V(ERROR_amp_N361099))  }
R_ERROR_amp_R12         ERROR_amp_N360787 ERROR_amp_N361129  1
C_ERROR_amp_C11         0 ERROR_amp_VCTRLM_NEW  1n
C_ERROR_amp_C1         VOS ERROR_amp_INNER_FB  20p
G_ERROR_amp_ABM2I1         ERROR_amp_N359583 ERROR_amp_N360871 VALUE {
+  IF(V(SS_NODE)>0.5, 1.75u, V(ERROR_amp_VCTRLM_NEW)*1u)    }
X_ERROR_amp_U10         FB ERROR_amp_N359505 ERROR_amp_N359501 COMP_BASIC_GEN
+  PARAMS: VDD=1 VSS=0 VTHRESH=0.5
X_ERROR_amp_U2         ERROR_amp_INNER_REF ERROR_amp_INNER_FB ERROR_amp_N361065
+  COMP_BASIC_GEN PARAMS: VDD=1 VSS=0 VTHRESH=0.5
R_ERROR_amp_R7         0 ERROR_amp_N360815  2.85k
X_ERROR_amp_U8         PAUSE P100 ERROR_amp_N359525 OR2_BASIC_GEN PARAMS: VDD=1
+  VSS=0 VTHRESH=500E-3
X_ERROR_amp_U7         ERROR_amp_N359595 ERROR_amp_N361129 SS_NODE
+  ERROR_amp_N361099 MUX2_BASIC_GEN PARAMS: VDD=1 VSS=0 VTHRESH=0.5
R_ERROR_amp_R20         0 ERROR_amp_N361163  50
X_ERROR_amp_S2    HS_ON 0 ERROR_amp_N360871 ERROR_amp_N360815
+  ErrorAmp_ERROR_amp_S2
R_ERROR_amp_R8         SWBY4 ERROR_amp_N360745  793.4k
X_Caprio_U12         Caprio_N23722 ISENSE_LS Caprio_N14289 COMP_BASIC_GEN
+  PARAMS: VDD=1 VSS=0 VTHRESH=0.5
X_Caprio_U14         Caprio_N15145 DRVH_PRE CAPRIO N20512 SRLATCHRHP_BASIC_GEN
+  PARAMS: VDD=1 VSS=0 VTHRESH=0.5
X_Caprio_U19         Caprio_N16390 Caprio_N16592 PAUSE AND2_BASIC_GEN PARAMS:
+  VDD=1 VSS=0 VTHRESH=500E-3
X_Caprio_U17         Caprio_N16592 Caprio_N17195  d_d2 PARAMS:
V_Caprio_V1         Caprio_N23722 0 1.5m
C_Caprio_C4         0 Caprio_N16592  1n
X_Caprio_U18         DRVH_PRE DRVL_PRE Caprio_N17195 NOR2_BASIC_GEN PARAMS:
+  VDD=1 VSS=0 VTHRESH=500E-3
X_Caprio_U16         MODE_LOGIC Caprio_N16390 INV_BASIC_GEN PARAMS: VDD=1 VSS=0
+  VTHRESH=500E-3
R_Caprio_R3         Caprio_N17195 Caprio_N16592  1.44k
X_Caprio_U13         DRVL_PRE Caprio_N14289 Caprio_N15145 AND2_BASIC_GEN
+  PARAMS: VDD=1 VSS=0 VTHRESH=500E-3
X_Curr_Limit_S5    Curr_Limit_N16803351 0 Curr_Limit_N16803282 0
+  Current_Limit_Curr_Limit_S5
R_Curr_Limit_R12         Curr_Limit_RS_8_CYCLE Curr_Limit_N16807543  150
C_Curr_Limit_C6         0 Curr_Limit_N16807543  1n IC=0
C_Curr_Limit_C10         0 Curr_Limit_HSLIMIT_THRESH  1n
X_Curr_Limit_U625         CLIMIT_HS Curr_Limit_N16807543 Curr_Limit_N16803351
+  OR2_BASIC_GEN PARAMS: VDD=1 VSS=0 VTHRESH=500E-3
X_Curr_Limit_U619         Curr_Limit_N16803282 Curr_Limit_N16803299
+  Curr_Limit_N16803181 COMP_BASIC_GEN PARAMS: VDD=1 VSS=0 VTHRESH=0.5
X_Curr_Limit_D11         Curr_Limit_N16774792 Curr_Limit_N16774858  d_d2 PARAMS:
+
V_Curr_Limit_V9         Curr_Limit_N16803299 0 7.5
X_Curr_Limit_U3         ISENSE_HS Curr_Limit_HSLIMIT_THRESH
+  Curr_Limit_N16849423 COMP_BASIC_GEN PARAMS: VDD=1 VSS=0 VTHRESH=0.5
V_Curr_Limit_V5         Curr_Limit_N55010 0 3.6
X_Curr_Limit_S3    Curr_Limit_HICCUP_RESET 0 Curr_Limit_N16774792 0
+  Current_Limit_Curr_Limit_S3
X_Curr_Limit_U4         Curr_Limit_N16849423 DRVH_PRE Curr_Limit_N16849411
+  AND2_BASIC_GEN PARAMS: VDD=1 VSS=0 VTHRESH=500E-3
X_Curr_Limit_D13         Curr_Limit_N16803282 Curr_Limit_N16803326  d_d2 PARAMS:
+
G_Curr_Limit_ABMII1         0 Curr_Limit_N16774792 VALUE {
+  V(Curr_Limit_N16774898)    }
R_Curr_Limit_R3         HICCUP Curr_Limit_N16774450  1
C_Curr_Limit_C8         0 Curr_Limit_N16849417  1n
X_Curr_Limit_D14         Curr_Limit_RS_8_CYCLE Curr_Limit_N16807543 d_d2
+  PARAMS:
C_Curr_Limit_C4         0 HICCUP  1n
R_Curr_Limit_R9         Curr_Limit_N16849411 Curr_Limit_N16849417  25
C_Curr_Limit_C9         0 Curr_Limit_N16803282  20n IC=0
X_Curr_Limit_U12         Curr_Limit_N16849417 Curr_Limit_N16849411  d_d2 PARAMS:
C_Curr_Limit_C5         0 Curr_Limit_N16805640  10n IC=0
C_Curr_Limit_C3         0 Curr_Limit_N16774792  20n IC=0
R_Curr_Limit_R7         0 Curr_Limit_N16774934  1e8
X_Curr_Limit_U618         DRVH_PRE Curr_Limit_N16803342 Curr_Limit_N16803354
+  MONOPOS_PS PARAMS: PW=20n
X_Curr_Limit_U13         Curr_Limit_N16849417 CLIMIT_HS BUF_BASIC_GEN PARAMS:
+  VDD=1 VSS=0 VTHRESH=0.5
R_Curr_Limit_R5         Curr_Limit_RS_8_CYCLE Curr_Limit_N16803181  1
C_Curr_Limit_C7         0 Curr_Limit_RS_8_CYCLE  1n
X_Curr_Limit_U612         Curr_Limit_N16774792 Curr_Limit_N16774804
+  Curr_Limit_N16774450 COMP_BASIC_GEN PARAMS: VDD=1 VSS=0 VTHRESH=0.5
R_Curr_Limit_R11         0 Curr_Limit_N16803354  1e8
X_Curr_Limit_D12         Curr_Limit_N16805640 HICCUP  d_d2 PARAMS:
X_Curr_Limit_U613         MIN_TOFF_CL Curr_Limit_N16774898 Curr_Limit_N16774934
+  MONOPOS_PS PARAMS: PW=20n
V_Curr_Limit_V3         Curr_Limit_N16774858 0 33
E_Curr_Limit_ABM5         Curr_Limit_N549041 0 VALUE { IF(V(VOS) < 0.6, 3.6,
+ V(Curr_Limit_N55010))   }
V_Curr_Limit_V8         Curr_Limit_N16803326 0 10
V_Curr_Limit_V4         Curr_Limit_N16774804 0 31.5
G_Curr_Limit_ABMII2         0 Curr_Limit_N16803282 VALUE {
+  V(Curr_Limit_N16803342)    }
R_Curr_Limit_R8         HICCUP Curr_Limit_N16805640  9.504k
R_Curr_Limit_R10         Curr_Limit_N549041 Curr_Limit_HSLIMIT_THRESH  1
X_Curr_Limit_U622         Curr_Limit_RS_8_CYCLE Curr_Limit_N16805640
+  Curr_Limit_HICCUP_RESET OR2_BASIC_GEN PARAMS: VDD=1 VSS=0 VTHRESH=500E-3
X_U7         MIN_TOFF MIN_TOFF_N INV_BASIC_GEN PARAMS: VDD=1 VSS=0
+  VTHRESH=500E-3
E_ABM1         L_DERATED 0 VALUE { 374.173E-12*abs(V(IL))**3 -
+  7.570E-9*abs(V(IL))**2 + 2.870E-9*abs(V(IL)) + 482.795E-9    }
R_R17         IL IL1  {686/1}
C_C3         0 SS_TR  5.0n
X_SoftStart_U9         SDWN_N SoftStart_SDWN INV_BASIC_GEN PARAMS: VDD=1 VSS=0
+  VTHRESH=500E-3
E_SoftStart_E2         SoftStart_N263709 0 VIN 0 -1
X_SoftStart_S2    PG 0 SoftStart_N247140 0 SoftStart_SoftStart_S2
C_SoftStart_C8         SoftStart_N263709 SoftStart_N247140  1n
X_SoftStart_S1    SoftStart_N234157 0 SS_TR 0 SoftStart_SoftStart_S1
E_SoftStart_ABM2         SoftStart_N247429 0 VALUE { {(LIMIT(V(SS_TR), 0, 1.25)
+
+ )*0.64}   }
X_SoftStart_U10         SoftStart_SDWN HICCUP SoftStart_N234157 OR2_BASIC_GEN
+  PARAMS: VDD=1 VSS=0 VTHRESH=500E-3
C_SoftStart_C7         0 SS_TR  5p
R_SoftStart_R11         SoftStart_N247134 SoftStart_N247140  18
E_SoftStart_ABM1         SoftStart_N220347 0 VALUE { IF(V(SDWN_N) < 0.5,0,1)
+  }
R_SoftStart_R12         SoftStart_N247170 SoftStart_N247140  10
C_SoftStart_C5         0 INT_VREF  1n
C_SoftStart_C4         0 SoftStart_N220353  1n
X_SoftStart_U11         SoftStart_N247134 0 d_dideal PARAMS:
V_SoftStart_V1         SoftStart_N221204 0 4.8
G_SoftStart_ABMII1         SoftStart_N221204 SS_TR VALUE {
+  V(SoftStart_N220353)*7.5u    }
X_SoftStart_U12         0 SoftStart_N247170 d_dideal PARAMS:
R_SoftStart_R10         SoftStart_N255172 INT_VREF  1
X_SoftStart_U8         SS_TR SoftStart_N221204  d_d2 PARAMS:
E_SoftStart_E3         SoftStart_N255172 0 SoftStart_N247429 SoftStart_N248006
+  1
R_SoftStart_R9         SoftStart_N220353 SoftStart_N220347  1
E_SoftStart_ABM3         SoftStart_N248006 0 VALUE { V(SoftStart_N247140)    }
C_C6         0 IL1  1n
R_R16         GND 0  1m
X_U8         SDWN_N SDWN INV_BASIC_GEN PARAMS: VDD=1 VSS=0 VTHRESH=500E-3
R_PWR_G_R1         PWR_G_N14627 PWR_G_N00497  1.44k
C_PWR_G_C1         0 PWR_G_N00497  1n
X_PWR_G_U10         PWR_G_N00497 EN_LOGIC UVLO_OUT PWR_G_N225619
+  NAND3_BASIC_GEN PARAMS: VDD=1 VSS=0 VTHRESH=500E-3
R_PWR_G_R4         PWR_G_N2234591 PWR_G_N222445  1
E_PWR_G_ABM7         PWR_G_N222172 0 VALUE { (V(PWR_G_N221839)+
+ +V(PWR_G_N222445))   }
E_PWR_G_ABM4         PWR_G_N2234591 0 VALUE { MAX(V(INT_VREF)*0.95,0.76)    }
C_PWR_G_C6         0 PWR_G_N221839  1n
X_PWR_G_U7         PWR_G_N00497 PWR_G_N14627  d_d2 PARAMS:
C_PWR_G_C4         0 PWR_G_N222445  1n
X_PWR_G_U9         PWR_G_N00497 PWR_G_OUT2 BUF_BASIC_GEN PARAMS: VDD=1 VSS=0
+  VTHRESH=0.5
R_PWR_G_R3         PWR_G_N222172 PWR_G_N14135  1
X_PWR_G_S1    PWR_G_N225619 0 PG 0 PG_SGND_PWR_G_S1
E_PWR_G_ABM6         PWR_G_N2233831 0 VALUE { (V(INT_VREF)*-0.05*
+ +V(PWR_G_OUT2))   }
R_PWR_G_R6         PWR_G_N2233831 PWR_G_N221839  1
X_PWR_G_U5         FB PWR_G_N14135 PWR_G_N14627 COMP_BASIC_GEN PARAMS: VDD=1
+  VSS=0 VTHRESH=0.5
C_PWR_G_C3         0 PWR_G_N14135  1n
X_U3         MIN_TON MIN_TON_N INV_BASIC_GEN PARAMS: VDD=1 VSS=0 VTHRESH=500E-3
R_R12         PVIN VIN  1m
R_R4         0 EN  400k
R_R3         N351928 N351938  200k
.ENDS TPS82084_TRANS
*$
.subckt TPS62085_H1 1 2 3 4
H_H1         3 4 VH_H1 1
VH_H1         1 2 0V
.ends TPS62085_H1
*$
.subckt Driver_U13_H1 1 2 3 4
H_U13_H1         3 4 VH_U13_H1 1
VH_U13_H1         1 2 0V
.ends Driver_U13_H1
*$
.subckt Driver_U13_S9 1 2 3 4
S_U13_S9         3 4 1 2 _U13_S9
RS_U13_S9         1 2 1G
.MODEL         _U13_S9 VSWITCH Roff=1e6 Ron=1 Voff=0.2 Von=0.8
.ends Driver_U13_S9
*$
.subckt Driver_U13_S10 1 2 3 4
S_U13_S10         3 4 1 2 _U13_S10
RS_U13_S10         1 2 1G
.MODEL         _U13_S10 VSWITCH Roff=1e6 Ron=1 Voff=0.2 Von=0.8
.ends Driver_U13_S10
*$
.subckt Driver_U13_S3 1 2 3 4
S_U13_S3         3 4 1 2 _U13_S3
RS_U13_S3         1 2 1G
.MODEL         _U13_S3 VSWITCH Roff=10e6 Ron=50m Voff=0.2 Von=0.8
.ends Driver_U13_S3
*$
.subckt Driver_U13_S6 1 2 3 4
S_U13_S6         3 4 1 2 _U13_S6
RS_U13_S6         1 2 1G
.MODEL         _U13_S6 VSWITCH Roff=1e6 Ron=1 Voff=0.2 Von=0.8
.ends Driver_U13_S6
*$
.subckt Driver_U13_S2 1 2 3 4
S_U13_S2         3 4 1 2 _U13_S2
RS_U13_S2         1 2 1G
.MODEL         _U13_S2 VSWITCH Roff=1e6 Ron=1 Voff=0.2 Von=0.8
.ends Driver_U13_S2
*$
.subckt Driver_U13_H2 1 2 3 4
H_U13_H2         3 4 VH_U13_H2 1
VH_U13_H2         1 2 0V
.ends Driver_U13_H2
*$
.subckt Driver_U13_S7 1 2 3 4
S_U13_S7         3 4 1 2 _U13_S7
RS_U13_S7         1 2 1G
.MODEL         _U13_S7 VSWITCH Roff=1e6 Ron=1 Voff=0.2 Von=0.8
.ends Driver_U13_S7
*$
.subckt Driver_U13_S5 1 2 3 4
S_U13_S5         3 4 1 2 _U13_S5
RS_U13_S5         1 2 1G
.MODEL         _U13_S5 VSWITCH Roff=1e6 Ron=1 Voff=0.2 Von=0.8
.ends Driver_U13_S5
*$
.subckt Driver_U13_S4 1 2 3 4
S_U13_S4         3 4 1 2 _U13_S4
RS_U13_S4         1 2 1G
.MODEL         _U13_S4 VSWITCH Roff=10e6 Ron=4m Voff=0.2 Von=0.8
.ends Driver_U13_S4
*$
.subckt Driver_U13_S8 1 2 3 4
S_U13_S8         3 4 1 2 _U13_S8
RS_U13_S8         1 2 1G
.MODEL         _U13_S8 VSWITCH Roff=1e6 Ron=1 Voff=0.2 Von=0.8
.ends Driver_U13_S8
*$
.subckt TPS62085_S11 1 2 3 4
S_S11         3 4 1 2 _S11
RS_S11         1 2 1G
.MODEL         _S11 VSWITCH Roff=100e6 Ron=200 Voff=0.2 Von=0.8
.ends TPS62085_S11
*$
.subckt Minton_U2_S1 1 2 3 4
S_U2_S1         3 4 1 2 _U2_S1
RS_U2_S1         1 2 1G
.MODEL         _U2_S1 VSWITCH Roff=100e6 Ron=1 Voff=0.2 Von=0.8
.ends Minton_U2_S1
*$
.subckt Minton_U2_S3 1 2 3 4
S_U2_S3         3 4 1 2 _U2_S3
RS_U2_S3         1 2 1G
.model _U2_S3 VSWITCH (roff={max(630k,1)} ron={min(630k,1)} voff={if(630k>1,0.8,0.2)} von={if(630k>1,0.2,0.8)})
.ends Minton_U2_S3
*$
.subckt Minton_U2_S2 1 2 3 4
S_U2_S2         3 4 1 2 _U2_S2
RS_U2_S2         1 2 1G
.MODEL         _U2_S2 VSWITCH Roff=10e6 Ron=1.0 Voff=0.2 Von=0.8
.ends Minton_U2_S2
*$
.subckt LogicTrans_U4_S1 1 2 3 4
S_U4_S1         3 4 1 2 _U4_S1
RS_U4_S1         1 2 1G
.MODEL         _U4_S1 VSWITCH Roff=100e6 Ron=400k Voff=0.2 Von=0.8
.ends LogicTrans_U4_S1
*$
.subckt LogicTrans_U4_S3 1 2 3 4
S_U4_S3         3 4 1 2 _U4_S3
RS_U4_S3         1 2 1G
.MODEL         _U4_S3 VSWITCH Roff=100e6 Ron=400k Voff=0.2 Von=0.8
.ends LogicTrans_U4_S3
*$
.subckt Mintoff_Modified_Min_Toff_S2 1 2 3 4
S_Min_Toff_S2         3 4 1 2 _Min_Toff_S2
RS_Min_Toff_S2         1 2 1G
.MODEL         _Min_Toff_S2 VSWITCH Roff=10e6 Ron=1m Voff=0.2 Von=0.8
.ends Mintoff_Modified_Min_Toff_S2
*$
.subckt Mintoff_Modified_Min_Toff_S1 1 2 3 4
S_Min_Toff_S1         3 4 1 2 _Min_Toff_S1
RS_Min_Toff_S1         1 2 1G
.MODEL         _Min_Toff_S1 VSWITCH Roff=10e6 Ron=1.0 Voff=0.2 Von=0.8
.ends Mintoff_Modified_Min_Toff_S1
*$
.subckt ErrorAmp_ERROR_amp_S3 1 2 3 4
S_ERROR_amp_S3         3 4 1 2 _ERROR_amp_S3
RS_ERROR_amp_S3         1 2 1G
.model _ERROR_amp_S3 VSWITCH (roff={max(10G,10k)} ron={min(10G,10k)} voff={if(10G>10k,0.9V,0.2V)} von={if(10G>10k,0.2V,0.9V)})
.ends ErrorAmp_ERROR_amp_S3
*$
.subckt ErrorAmp_ERROR_amp_S1 1 2 3 4
S_ERROR_amp_S1         3 4 1 2 _ERROR_amp_S1
RS_ERROR_amp_S1         1 2 1G
.MODEL         _ERROR_amp_S1 VSWITCH Roff=1000e6 Ron=10k Voff=0.4V Von=0.8V
.ends ErrorAmp_ERROR_amp_S1
*$
.subckt ErrorAmp_ERROR_amp_S2 1 2 3 4
S_ERROR_amp_S2         3 4 1 2 _ERROR_amp_S2
RS_ERROR_amp_S2         1 2 1G
.MODEL         _ERROR_amp_S2 VSWITCH Roff=100e6 Ron=1m Voff=0.4V Von=0.8V
.ends ErrorAmp_ERROR_amp_S2
*$
.subckt Current_Limit_Curr_Limit_S5 1 2 3 4
S_Curr_Limit_S5         3 4 1 2 _Curr_Limit_S5
RS_Curr_Limit_S5         1 2 1G
.MODEL         _Curr_Limit_S5 VSWITCH Roff=1e6 Ron=1m Voff=0.25 Von=0.75
.ends Current_Limit_Curr_Limit_S5
*$
.subckt Current_Limit_Curr_Limit_S3 1 2 3 4
S_Curr_Limit_S3         3 4 1 2 _Curr_Limit_S3
RS_Curr_Limit_S3         1 2 1G
.MODEL         _Curr_Limit_S3 VSWITCH Roff=1e6 Ron=1m Voff=0.25 Von=0.75
.ends Current_Limit_Curr_Limit_S3
*$
.subckt SoftStart_SoftStart_S2 1 2 3 4
S_SoftStart_S2         3 4 1 2 _SoftStart_S2
RS_SoftStart_S2         1 2 1G
.MODEL         _SoftStart_S2 VSWITCH Roff=1e6 Ron=1m Voff=0.8V Von=.2V
.ends SoftStart_SoftStart_S2
*$
.subckt SoftStart_SoftStart_S1 1 2 3 4
S_SoftStart_S1         3 4 1 2 _SoftStart_S1
RS_SoftStart_S1         1 2 1G
.MODEL         _SoftStart_S1 VSWITCH Roff=1e9 Ron=100 Voff=0.2 Von=0.8
.ends SoftStart_SoftStart_S1
*$
.subckt PG_SGND_PWR_G_S1 1 2 3 4
S_PWR_G_S1         3 4 1 2 _PWR_G_S1
RS_PWR_G_S1         1 2 1G
.MODEL         _PWR_G_S1 VSWITCH Roff=30e6 Ron=150 Voff=0.2V Von=0.8
.ends PG_SGND_PWR_G_S1
*$
.subckt d_d2 1 2
d1 1 2 dd1
.model dd1 d
+ is=1e-010
+ rs=0.005
+ n=0.1
.ends d_d2
*$
.model D_D1 d
+ is=1e-010
+ rs=0.005
+ n=0.1
*$
.SUBCKT INV_BASIC_GEN A  Y PARAMS: VDD=1 VSS=0 VTHRESH=0.5
E_ABMGATE    YINT 0 VALUE {{IF(V(A) > {VTHRESH} ,
+ {VSS},{VDD})}}
RINT YINT Y 1
CINT Y 0 1n
.ENDS INV_BASIC_GEN
*$
.SUBCKT COMP_BASIC_GEN INP INM Y PARAMS: VDD=1 VSS=0 VTHRESH=0.5
E_ABM Yint 0 VALUE {IF (V(INP) >
+ V(INM), {VDD},{VSS})}
R1 Yint Y 1
C1 Y 0 1n
.ENDS COMP_BASIC_GEN
*$
.SUBCKT AND2_BASIC_GEN A B Y PARAMS: VDD=1 VSS=0 VTHRESH=0.5
E_ABMGATE    YINT 0 VALUE {{IF(V(A) > {VTHRESH}  &
+ V(B) > {VTHRESH},{VDD},{VSS})}}
RINT YINT Y 1
CINT Y 0 1n
.ENDS AND2_BASIC_GEN
*$
.SUBCKT OR2_BASIC_GEN A B Y PARAMS: VDD=1 VSS=0 VTHRESH=0.5
E_ABMGATE    YINT 0 VALUE {{IF(V(A) > {VTHRESH}  |
+ V(B) > {VTHRESH},{VDD},{VSS})}}
RINT YINT Y 1
CINT Y 0 1n
.ENDS OR2_BASIC_GEN
*$
.SUBCKT BUF_BASIC_GEN A  Y PARAMS: VDD=1 VSS=0 VTHRESH=0.5
E_ABMGATE    YINT 0 VALUE {{IF(V(A) > {VTHRESH} ,
+ {VDD},{VSS})}}
RINT YINT Y 1
CINT Y 0 1n
.ENDS BUF_BASIC_GEN
*$
.SUBCKT MONOPOS_PS in Q Qn PARAMS: PW=1u
VS VSUP 0 DC 1
GIN VSUP YA VALUE={IF(V(IN)>0.5, V(VSUP)/1000K, 0)}
GDIS YA 0 VALUE={IF(V(IN)>0.5,0, V(YA)/1m)}
CIN YA 0 1n IC=0
RIN YA 0 1e11
EABM1 YTD 0 VALUE={IF(V(YA)> {PW*1000}, 1, 0)}
RYTD YTD 0 1e11
EXOR P 0 VALUE={IF(V(YTD) > 0.5 != V(IN) > .5, 1, 0)}
ROUTpp2 P 0 1e11
EAND1 Q1 0 VALUE={ IF(V(P)>0.5 & V(IN)>0.5, 1, 0)}
Ro1 Q1 Q 1m
Co1 Q 0 1p
ROUT2 Q 0 1e11
EAND2 Qn1 0 VALUE={ IF(V(Q)>0.5, 0, 1)}
Ro2 Qn1 Qn 1m
Co2 Qn 0 1p
ROUT4 Qn 0 1e11
.ENDS MONOPOS_PS
*$
.SUBCKT AND3_BASIC_GEN A B C Y PARAMS: VDD=1 VSS=0 VTHRESH=0.5
E_ABMGATE    YINT 0 VALUE {{IF(V(A) > {VTHRESH}  &
+ V(B) > {VTHRESH} &
+ V(C) > {VTHRESH},{VDD},{VSS})}}
RINT YINT Y 1
CINT Y 0 1n
.ENDS AND3_BASIC_GEN
*$
.SUBCKT NOR2_BASIC_GEN A B Y PARAMS: VDD=1 VSS=0 VTHRESH=0.5
E_ABMGATE    YINT 0 VALUE {{IF(V(A) > {VTHRESH}  |
+ V(B) > {VTHRESH},{VSS},{VDD})}}
RINT YINT Y 1
CINT Y 0 1n
.ENDS NOR2_BASIC_GEN
*$
.SUBCKT AND4_BASIC_GEN A B C D Y PARAMS: VDD=1 VSS=0 VTHRESH=0.5
E_ABMGATE    YINT 0 VALUE {{IF(V(A) > {VTHRESH}  &
+ V(B) > {VTHRESH} &
+ V(C) > {VTHRESH} &
+ V(D) > {VTHRESH},{VDD},{VSS})}}
RINT YINT Y 1
CINT Y 0 1n
.ENDS AND4_BASIC_GEN
*$
.SUBCKT SRLATCHRHP_BASIC_GEN S R Q QB PARAMS: VDD=1 VSS=0 VTHRESH=0.5
GQ 0 Qint VALUE = {IF(V(R) > {VTHRESH},-5,IF(V(S)>{VTHRESH},5, 0))}
CQint Qint 0 1n
RQint Qint 0 1000MEG
D_D10 Qint MY5 D_D1
V1 MY5 0 {VDD}
D_D11 MYVSS Qint D_D1
V2 MYVSS 0 {VSS}
EQ Qqq 0 Qint 0 1
X3 Qqq Qqqd1 BUF_BASIC_GEN PARAMS: VDD={VDD} VSS={VSS} VTHRESH={VTHRESH}
RQq Qqqd1 Q 1
EQb Qbr 0 VALUE = {IF( V(Q) > {VTHRESH}, {VSS},{VDD})}
RQb Qbr QB 1
Cdummy1 Q 0 1n
Cdummy2 QB 0 1n
.IC V(Qint) {VSS}
.ENDS SRLATCHRHP_BASIC_GEN
*$
.SUBCKT BUF_DELAY_BASIC_GEN A  Y PARAMS: VDD=1 VSS=0 VTHRESH=0.5 DELAY = 10n
E_ABMGATE1    YINT1 0 VALUE {{IF(V(A) > {VTHRESH} ,
+ {VDD},{VSS})}}
RINT YINT1 YINT2 1
CINT YINT2 0 {DELAY*1.3}
E_ABMGATE2    YINT3 0 VALUE {{IF(V(YINT2) > {VTHRESH} ,
+ {VDD},{VSS})}}
RINT2 YINT3 Y 1
CINT2 Y 0 1n
.ENDS BUF_DELAY_BASIC_GEN
*$
.SUBCKT OR3_BASIC_GEN A B C Y PARAMS: VDD=1 VSS=0 VTHRESH=0.5
E_ABMGATE    YINT 0 VALUE {{IF(V(A) > {VTHRESH}  |
+ V(B) > {VTHRESH} |
+ V(C) > {VTHRESH},{VDD},{VSS})}}
RINT YINT Y 1
CINT Y 0 1n
.ENDS OR3_BASIC_GEN
*$
.SUBCKT MUX2_BASIC_GEN A B S Y PARAMS: VDD=1 VSS=0 VTHRESH=0.5
E_ABMGATE  YINT 0 VALUE {{IF(V(S) > {VTHRESH},
+ V(B),V(A))}}
RINT YINT Y 1
CINT Y 0 1n
.ENDS MUX2_BASIC_GEN
*$
.SUBCKT NAND3_BASIC_GEN A B C Y PARAMS: VDD=1 VSS=0 VTHRESH=0.5
E_ABMGATE    YINT 0 VALUE {{IF(V(A) > {VTHRESH}  &
+ V(B) > {VTHRESH} &
+ V(C) > {VTHRESH},{VSS},{VDD})}}
RINT YINT Y 1
CINT Y 0 1n
.ENDS NAND3_BASIC_GEN
*$
.SUBCKT INV_DELAY_BASIC_GEN A  Y PARAMS: VDD=1 VSS=0 VTHRESH=0.5 DELAY = 10n
E_ABMGATE1    YINT1 0 VALUE {{IF(V(A) > {VTHRESH} ,
+ {VDD},{VSS})}}
RINT YINT1 YINT2 1
CINT YINT2 0 {DELAY*1.3}
E_ABMGATE2    YINT3 0 VALUE {{IF(V(YINT2) > {VTHRESH} ,
+ {VSS},{VDD})}}
RINT2 YINT3 Y 1
CINT2 Y 0 1n
.ENDS INV_DELAY_BASIC_GEN
*$
.SUBCKT OR4_BASIC_GEN A B C D Y PARAMS: VDD=1 VSS=0 VTHRESH=0.5
E_ABMGATE    YINT 0 VALUE {{IF(V(A) > {VTHRESH}  |
+ V(B) > {VTHRESH} |
+ V(C) > {VTHRESH} |
+ V(D) > {VTHRESH},{VDD},{VSS})}}
RINT YINT Y 1
CINT Y 0 1n
.ENDS OR4_BASIC_GEN
*$
.SUBCKT VARIIND 1 2 CTRL
GC 1 2 Value={V(INT)/V(CTRL)}
GINT 0 INT Value={V(1,2)}
CINT INT 0 1
RINT INT 0 10Meg
.ENDS
*$
.subckt d_dideal 1 2
d1 1 2 dd1
.model dd1 d
+ is=1e-015
+ rs=0.01
+ n=0.001
.ends d_dideal
*$
.SUBCKT CESR 1 2 PARAMS: C=10u ESR=2m ESL=510p IC=0
C1 1 INT1 {C} IC={IC}
R1 INT1 INT2 {ESR}
L1 INT2 2 {ESL}
.ENDS CESR
*$

Xentry EN FB GND_0 GND_1 PG VIN_0 VIN_1 VOUT PAD TPS82084_TRANS
.ENDS library_simulation_spice_subcircuit_2
.SUBCKT library_simulation_spice_subcircuit_3 EN FB GND_0 GND_1 PG VIN_0 VIN_1 VOUT PAD
*$
**TPS82085

*****************************************************************************
* (C) Copyright 2015 Texas Instruments Incorporated. All rights reserved.
*****************************************************************************
** This model is designed as an aid for customers of Texas Instruments.
** TI and its licensors and suppliers make no warranties, either expressed
** or implied, with respect to this model, including the warranties of
** merchantability or fitness for a particular purpose. The model is
** provided solely on an "as is" basis. The entire risk as to its quality
** and performance is with the customer
*****************************************************************************
*
* This model is subject to change without notice. Texas Instruments
* Incorporated is not responsible for updating this model.
*
*****************************************************************************
* Released by: WEBENCH Design Center, Texas Instruments Inc.
* Part: TPS82085
* Date: 08JUL2015
* Model Type: Transient
* Simulator: PSpice
* Simulator Version: 16.2
* EVM Order Number: TPS82085EVM-672
* EVM Users Guide: SLVUAC5– November 2014
* Datasheet: SLVSCN4 – OCTOBER 2014
* Model Version: Final 1.00
*
*****************************************************************************
*
* Updates:
* Final 1.00
* Release to Web
*
*
***************************************
.SUBCKT TPS82085_TRANS EN FB GND_0 GND_1 PG VIN_0 VIN_1 VOUT  PAD PARAMS: SS=1
Rin1 VIN_0 VIN  1m
Rin2 VIN_1 VIN  1m
Rgnd1 GND_0 GND 1m
Rgnd2 GND_1 GND 1m
vvout VOUT VOS 0
R_PWM_R2         PWM_N290478 PWM_LS_SET  1
X_PWM_U30         LV_DETECTED PWM_CAPRIO_Z PWM_NCV AND2_BASIC_GEN PARAMS: VDD=1
+  VSS=0 VTHRESH=500E-3
X_PWM_U28         PWM_N167763 DRVL_PRE PWM_N167705 AND2_BASIC_GEN PARAMS: VDD=1
+  VSS=0 VTHRESH=500E-3
X_PWM_U8         PWM_N251358 PWM_HS_RST HS_ON N167899 SRLATCHRHP_BASIC_GEN
+  PARAMS: VDD=1 VSS=0 VTHRESH=0.5
X_PWM_U797         PWM_N168069 PWM_CAPRIO_Z SDWN_N PWM_LDRV_PBIAS PWM_N290478
+  AND4_BASIC_GEN PARAMS: VDD=1 VSS=0 VTHRESH=500E-3
X_PWM_U33         PWM_NCV_Z PWM_N211078 PWM_HS_SET AND2_BASIC_GEN PARAMS: VDD=1
+  VSS=0 VTHRESH=500E-3
X_PWM_U801         MIN_TOFF_CL_N SDWN PWM_N167797 OR2_BASIC_GEN PARAMS: VDD=1
+  VSS=0 VTHRESH=500E-3
C_PWM_C2         0 PWM_LS_SET  1n
X_PWM_U12         PWM_N167835 PWM_HS_RST  d_d2 PARAMS:
C_PWM_C1         0 PWM_HS_RST  10p
X_PWM_U24         MIN_TOFF_CL_N PWM_MIN_TOFF_CL INV_BASIC_GEN PARAMS: VDD=1
+  VSS=0 VTHRESH=500E-3
X_PWM_U14         HS_ON PWM_HS_ON_N INV_BASIC_GEN PARAMS: VDD=1 VSS=0
+  VTHRESH=500E-3
R_PWM_R3         PWM_N290780 PWM_N168025  1
X_PWM_U29         PWMIN PWM_N167797 PWM_N167659 PWM_PWM AND3_BASIC_GEN PARAMS:
+  VDD=1 VSS=0 VTHRESH=500E-3
X_PWM_U19         LV_DETECTED PWM_LOW_VO_DETECT_Z INV_BASIC_GEN PARAMS: VDD=1
+  VSS=0 VTHRESH=500E-3
X_PWM_U26         PWM_N167907 MIN_TON_N MIN_TON_ABS_N PWM_N167839
+  AND3_BASIC_GEN PARAMS: VDD=1 VSS=0 VTHRESH=500E-3
X_PWM_U804         PWM_N167839 SDWN PWM_MIN_TOFF_CL PWM_N167835 OR3_BASIC_GEN
+  PARAMS: VDD=1 VSS=0 VTHRESH=500E-3
C_PWM_C3         0 PWM_N168025  1n
X_PWM_U798         CAPRIO SDWN PWM_N167635 PWM_LDRV_PBIASBAR PWM_DEFAULT_PATH_L
+  OR4_BASIC_GEN PARAMS: VDD=1 VSS=0 VTHRESH=500E-3
X_PWM_U795         PWMIN SDWN PWM_LDRV_PBIAS PWM_LDRV_PBIASBAR
+  SRLATCHRHP_BASIC_GEN PARAMS: VDD=1 VSS=0 VTHRESH=0.5
R_PWM_R4         PWM_HS_SET PWM_N251358  1
X_PWM_U21         PWM_NCV PWM_NCV_Z INV_BASIC_GEN PARAMS: VDD=1 VSS=0
+  VTHRESH=500E-3
X_PWM_U22         MIN_TOFF_N PWM_PWM PWM_N167635 AND2_BASIC_GEN PARAMS: VDD=1
+  VSS=0 VTHRESH=500E-3
X_PWM_U20         LS_ON PWM_LS_ON_N INV_BASIC_GEN PARAMS: VDD=1 VSS=0
+  VTHRESH=500E-3
R_PWM_R5         HS_ON HS_ON  1
X_PWM_U7         PWM_LS_ON_PRE SDWN_N PWM_PWM PWM_N211078 AND3_BASIC_GEN
+  PARAMS: VDD=1 VSS=0 VTHRESH=500E-3
X_PWM_U13         PWM_HS_ON_N PWM_N167907 PWM_N168069 AND2_BASIC_GEN PARAMS:
+  VDD=1 VSS=0 VTHRESH=500E-3
C_PWM_C4         0 PWM_N251358  1n
X_PWM_U15         PWM_HS_ON_N PWM_N168025 LS_ON AND2_BASIC_GEN PARAMS: VDD=1
+  VSS=0 VTHRESH=500E-3
C_PWM_C5         0 HS_ON  1n
X_PWM_U16         PWM_DEFAULT_PATH_L PWM_NCV_Z PWM_LS_RST AND2_BASIC_GEN
+  PARAMS: VDD=1 VSS=0 VTHRESH=500E-3
X_PWM_U27         PWM_N167705 PWM_N167797 N167801 PWM_N167659
+  SRLATCHRHP_BASIC_GEN PARAMS: VDD=1 VSS=0 VTHRESH=0.5
X_PWM_U9         PWM_PWM PWM_N167907 INV_BASIC_GEN PARAMS: VDD=1 VSS=0
+  VTHRESH=500E-3
X_PWM_U17         CAPRIO PWM_CAPRIO_Z INV_BASIC_GEN PARAMS: VDD=1 VSS=0
+  VTHRESH=500E-3
X_PWM_U18         PWM_LS_SET PWM_LS_RST PWM_N290780 PWM_LS_ON_PRE
+  SRLATCHRHP_BASIC_GEN PARAMS: VDD=1 VSS=0 VTHRESH=0.5
X_PWM_U800         DRVL_PRE PWM_N167763 INV_DELAY_BASIC_GEN PARAMS: VDD=1 VSS=0
+  VTHRESH=0.5 DELAY=40n
R_PWM_R1         PWM_N167835 PWM_HS_RST  800
X_U9         MIN_TON_ABS MIN_TON_ABS_N INV_BASIC_GEN PARAMS: VDD=1 VSS=0
+  VTHRESH=500E-3
X_H1    SW N14722982 IL 0 TPS62085_H1
X_U17         MIN_TOFF_CL MIN_TOFF_CL_N INV_BASIC_GEN PARAMS: VDD=1 VSS=0
+  VTHRESH=500E-3
X_U15         ABS_MIN_TOFF ABS_MIN_TOFF_N INV_BASIC_GEN PARAMS: VDD=1 VSS=0
+  VTHRESH=500E-3
X_U13_U4         U13_N33832 U13_N33808 BUF_DELAY_BASIC_GEN PARAMS: VDD=1 VSS=0
+  VTHRESH=0.5 DELAY=6n
R_U13_R2         U13_N16808550 VAVG  10k
X_U13_H1    PVIN U13_N16766543 ISENSE_HS 0 Driver_U13_H1
C_U13_C2         0 VAVG  1n
X_U13_D11         SW U13_N16766543  d_d2 PARAMS:
X_U13_S9    U13_DRVH_PRE_N 0 CN_INT 0 Driver_U13_S9
E_U13_E1         U13_N16808550 0 U13_N16808483 0 1
X_U13_U2         U13_N33760 U13_N33764 DRVH_PRE AND2_BASIC_GEN PARAMS: VDD=1
+  VSS=0 VTHRESH=500E-3
X_U13_S10    DRVH_PRE 0 PVIN CN_INT Driver_U13_S10
X_U13_S3    U13_DRVH 0 U13_N16766543 SW Driver_U13_S3
R_U13_R3         VOS U13_N16808483  1
X_U13_U11         HS_ON U13_N33760 BUF_DELAY_BASIC_GEN PARAMS: VDD=1 VSS=0
+  VTHRESH=0.5 DELAY=8n
X_U13_S6    U13_DRVL_PRE_N 0 U13_DRVL 0 Driver_U13_S6
X_U13_S2    DRVH_PRE 0 CP_INT U13_DRVH Driver_U13_S2
X_U13_U616         DRVL_PRE U13_DRVL_PRE_N INV_BASIC_GEN PARAMS: VDD=1 VSS=0
+  VTHRESH=500E-3
X_U13_U610         DRVH_PRE U13_DRVH_PRE_N INV_BASIC_GEN PARAMS: VDD=1 VSS=0
+  VTHRESH=500E-3
X_U13_H2    U13_N16766531 0 0 ISENSE_LS Driver_U13_H2
X_U13_D12         U13_N16766531 SW  d_d2 PARAMS:
X_U13_S7    DRVL_PRE 0 PVIN U13_DRVL Driver_U13_S7
C_U13_C3         0 U13_N16808483  1n
X_U13_U12         LS_ON U13_N33832 BUF_DELAY_BASIC_GEN PARAMS: VDD=1 VSS=0
+  VTHRESH=0.5 DELAY=8n
X_U13_S5    U13_DRVH_PRE_N 0 U13_DRVH 0 Driver_U13_S5
E_U13_ABM1         U13_N16808518 0 VALUE { IF(V(DRVH_PRE) >0.5 ,
+ V(ISENSE_HS),
+ V(ISENSE_LS) )  }
X_U13_S4    U13_DRVL 0 SW U13_N16766531 Driver_U13_S4
X_U13_U3         U13_N33832 U13_N33808 DRVL_PRE AND2_BASIC_GEN PARAMS: VDD=1
+  VSS=0 VTHRESH=500E-3
X_U13_S8    U13_DRVH_PRE_N 0 PVIN CP_INT Driver_U13_S8
R_U13_R1         U13_N16808518 IAVG  1k
X_U13_U1         U13_N33760 U13_N33764 BUF_DELAY_BASIC_GEN PARAMS: VDD=1 VSS=0
+  VTHRESH=0.5 DELAY=6n
C_U13_C1         0 IAVG  1n
R_Enable_R2         Enable_N06376 Enable_N06443  1
X_Enable_U10         HICCUP Enable_N56049 INV_BASIC_GEN PARAMS: VDD=1 VSS=0
+  VTHRESH=500E-3
E_Enable_ABM2         Enable_N522161 0 VALUE { (V(Enable_N06443) + 2.4)    }
C_Enable_C3         0 Enable_N03743  1n
R_Enable_R3         Enable_N522161 Enable_N03743  1
C_Enable_C2         0 Enable_N06443  1n
X_Enable_U11         Enable_N56049 UVLO_OUT EN_LOGIC Enable_N12192 SDWN_N
+  AND4_BASIC_GEN PARAMS: VDD=1 VSS=0 VTHRESH=500E-3
X_Enable_U5         VIN Enable_N03743 UVLO_OUT COMP_BASIC_GEN PARAMS: VDD=1
+  VSS=0 VTHRESH=0.5
E_Enable_ABM1         Enable_N06376 0 VALUE { (V(UVLO_OUT) * -200m)    }
V_Enable_V3         Enable_N12192 0
+PULSE {SS} 1 1u 10n 10n 1000 2000
X_U33         N14588914 N14589344 LV_DETECTED AND2_BASIC_GEN PARAMS: VDD=1
+  VSS=0 VTHRESH=500E-3
X_S11    N351522 0 VOS 0 TPS62085_S11
V_V1         MODE 0 0Vdc
R_R11         VIN VIN  1m
C_C2         0 N351938  1n
C_C5         CN_INT CP_INT  10n
V_V4         N365925 0 300m
X_U34         N14722982 N14723064 L_DERATED VARIIND
X_U2_U12         DRVH_PRE U2_N19880 INV_BASIC_GEN PARAMS: VDD=1 VSS=0
+  VTHRESH=500E-3
C_U2_C3         0 U2_N14352  5p
X_U2_U9         U2_N14352 U2_N10820 MIN_TON COMP_BASIC_GEN PARAMS: VDD=1 VSS=0
+  VTHRESH=0.5
X_U2_U13         U2_N19580 U2_N19824 MIN_TON_ABS COMP_BASIC_GEN PARAMS: VDD=1
+  VSS=0 VTHRESH=0.5
R_U2_R2         SWBY4 U2_N14352  1.925MEG
X_U2_S1    U2_N12733 0 U2_N10820 0 Minton_U2_S1
X_U2_S3    LV_DETECTED 0 U2_N21998 U2_N10820 Minton_U2_S3
C_U2_C4         0 U2_N19824  480p
C_U2_C2         0 U2_N10820  1.9p
V_U2_V4         U2_N19580 0 667m
X_U2_U10         U2_N19824 U2_N19572  d_d2 PARAMS:
R_U2_R1         U2_N21998 VIN  860k
X_U2_S2    U2_N19880 0 U2_N19824 0 Minton_U2_S2
V_U2_V5         U2_N19572 0 1.2
X_U2_U11         DRVH_PRE U2_N12733 INV_BASIC_GEN PARAMS: VDD=1 VSS=0
+  VTHRESH=500E-3
I_U2_I1         U2_N19572 U2_N19824 DC 6.4m
X_U19         N351938 N351928  d_d2 PARAMS:
X_U27         HICCUP SDWN N351522 OR2_BASIC_GEN PARAMS: VDD=1 VSS=0
+  VTHRESH=500E-3
R_R5         0 0  400k
X_U16         SS_NODE N14589344 INV_BASIC_GEN PARAMS: VDD=1 VSS=0
+  VTHRESH=500E-3
X_U18         N365925 VOS N14588914 COMP_BASIC_GEN PARAMS: VDD=1 VSS=0
+  VTHRESH=0.5
X_U26         N351938 P100 BUF_BASIC_GEN PARAMS: VDD=1 VSS=0 VTHRESH=0.5
X_U4_U3         FSW_LOGIC U4_N19391 INV_BASIC_GEN PARAMS: VDD=1 VSS=0
+  VTHRESH=500E-3
C_U4_C1         0 EN_LOGIC  1n
R_U4_R2         U4_N15867 MODE_LOGIC  1
R_U4_R1         U4_N15535 EN_LOGIC  1
C_U4_C4         0 FSW_LOGIC  1n
R_U4_R4         U4_N17314 FSW_LOGIC  1
E_U4_ABM2         U4_N15867 0 VALUE { IF(V(MODE) > 0.8,1,0)    }
E_U4_ABM4         U4_N17314 0 VALUE { IF(V(LV_DETECTED) > 0.895,1,0)    }
X_U4_S1    U4_N18546 0 EN 0 LogicTrans_U4_S1
C_U4_C2         0 MODE_LOGIC  1n
X_U4_U1         EN_LOGIC U4_N18546 INV_BASIC_GEN PARAMS: VDD=1 VSS=0
+  VTHRESH=500E-3
E_U4_ABM1         U4_N15535 0 VALUE { IF(V(EN) > 0.895,1,0)    }
X_U4_S3    U4_N19391 0 LV_DETECTED 0 LogicTrans_U4_S3
R_RDCR         N14723064 VOS  27m
X_Min_Toff_U9         Min_Toff_N16777542 Min_Toff_N16777534 ABS_MIN_TOFF
+  COMP_BASIC_GEN PARAMS: VDD=1 VSS=0 VTHRESH=0.5
V_Min_Toff_V4         Min_Toff_N16777542 0 667m
X_Min_Toff_U31         MIN_TOFF Min_Toff_VOUT_LOW_DETECTED_Z N16796980
+  AND2_BASIC_GEN PARAMS: VDD=1 VSS=0 VTHRESH=500E-3
X_Min_Toff_U24         LV_DETECTED Min_Toff_VOUT_LOW_DETECTED_Z INV_BASIC_GEN
+  PARAMS: VDD=1 VSS=0 VTHRESH=500E-3
C_Min_Toff_C2         0 Min_Toff_N16777534  480f
X_Min_Toff_U23         Min_Toff_N16777544 Min_Toff_TOFF_RS MIN_TOFF_CL
+  Min_Toff_N16777627 SRLATCHRHP_BASIC_GEN PARAMS: VDD=1 VSS=0 VTHRESH=0.5
I_Min_Toff_I1         Min_Toff_N16777530 Min_Toff_N16777534 DC 6.4u
X_Min_Toff_U22         CAPRIO Min_Toff_CAPRIO_Z INV_BASIC_GEN PARAMS: VDD=1
+  VSS=0 VTHRESH=500E-3
X_Min_Toff_U622         MIN_TOFF_CL ABS_MIN_TOFF MIN_TOFF OR2_BASIC_GEN PARAMS:
+  VDD=1 VSS=0 VTHRESH=500E-3
X_Min_Toff_U613         CLIMIT_HS Min_Toff_N16777544 Min_Toff_N16777587
+  MONOPOS_PS PARAMS: PW=20n
E_Min_Toff_ABM1         Min_Toff_N16777809 0 VALUE { IF(V(Min_Toff_N16777590) <
+  (V(VIN)/2) , 1, 0)    }
R_Min_Toff_R272         Min_Toff_N16777779 Min_Toff_N16777771  3.5
X_Min_Toff_S2    Min_Toff_N16777627 0 VIN Min_Toff_N16777590
+  Mintoff_Modified_Min_Toff_S2
C_Min_Toff_C172         0 Min_Toff_N16777771  1n
X_Min_Toff_U30         Min_Toff_VOUT_LOW_DETECTED_Z CAPRIO Min_Toff_NCV
+  AND2_BASIC_GEN PARAMS: VDD=1 VSS=0 VTHRESH=500E-3
C_Min_Toff_C3         Min_Toff_N16777590 VIN  600f
X_Min_Toff_U621         Min_Toff_N16777779 Min_Toff_N16777771 Min_Toff_TOFF_RS
+  OR2_BASIC_GEN PARAMS: VDD=1 VSS=0 VTHRESH=500E-3
X_Min_Toff_U21         Min_Toff_NCV Min_Toff_NCV_Z INV_BASIC_GEN PARAMS: VDD=1
+  VSS=0 VTHRESH=500E-3
R_Min_Toff_R7         0 Min_Toff_N16777587  1e8
R_Min_Toff_R1         Min_Toff_N16777809 Min_Toff_N16777779  1
G_Min_Toff_ABMI1         Min_Toff_N16777590 0 VALUE {  V(VOS)/210k    }
C_Min_Toff_C4         0 Min_Toff_N16777779  1n
V_Min_Toff_V5         Min_Toff_N16777530 0 1.2
X_Min_Toff_U623         Min_Toff_TOFF_RS Min_Toff_VOUT_LOW_DETECTED_Z N16785568
+  OR2_BASIC_GEN PARAMS: VDD=1 VSS=0 VTHRESH=500E-3
X_Min_Toff_U10         Min_Toff_N16777534 Min_Toff_N16777530  d_d2 PARAMS:
X_Min_Toff_U12         Min_Toff_N16777779 Min_Toff_N16777771  d_d2 PARAMS:
X_Min_Toff_S1    Min_Toff_N16777948 0 Min_Toff_N16777534 0
+  Mintoff_Modified_Min_Toff_S1
X_Min_Toff_U11         DRVL_PRE Min_Toff_N16777948 INV_BASIC_GEN PARAMS: VDD=1
+  VSS=0 VTHRESH=500E-3
C_C4         FB VOS  25p
E_GAIN1         N351928 0 VALUE {1 * V(HS_ON)}
V_ERROR_amp_V2         ERROR_amp_N360843 0 0.76
X_ERROR_amp_U1         ERROR_amp_N360871 ERROR_amp_N359583  d_d2 PARAMS:
T_ERROR_amp_T1         ERROR_amp_N361065 0 ERROR_amp_N361163 0 Z0=50 TD=300n
E_ERROR_amp_ABM4         ERROR_amp_N359573 0 VALUE { LIMIT(((V(INT_VREF)
+  -V(FB))*5.3u),
+ 500n,-500n)   }
X_ERROR_amp_U6         ERROR_amp_INNER_REF ERROR_amp_INNER_REF_CLAMP d_d2
+  PARAMS:
X_ERROR_amp_S3    SDWN_N 0 ERROR_amp_INNER_FB ERROR_amp_INNER_REF
+  ErrorAmp_ERROR_amp_S3
X_ERROR_amp_U9         0 ERROR_amp_INNER_REF  d_d2 PARAMS:
X_ERROR_amp_U11         ERROR_amp_N361065 ERROR_amp_N361163 PAUSE PWMIN
+  MUX2_BASIC_GEN PARAMS: VDD=1 VSS=0 VTHRESH=0.5
R_ERROR_amp_R13         ERROR_amp_VCLAMP ERROR_amp_N359573  2
R_ERROR_amp_R3         ERROR_amp_N360745 SW  644k
C_ERROR_amp_C9         0 ERROR_amp_N359595  1n
X_ERROR_amp_U12         LV_DETECTED ERROR_amp_N359525 ERROR_amp_FBREF_SHORT
+  OR2_BASIC_GEN PARAMS: VDD=1 VSS=0 VTHRESH=500E-3
X_ERROR_amp_U4         ERROR_amp_N360883 ERROR_amp_N360937 N361141 SS_NODE
+  SRLATCHRHP_BASIC_GEN PARAMS: VDD=1 VSS=0 VTHRESH=0.5
E_ERROR_amp_ABM8         ERROR_amp_N359551 0 VALUE { IF(V(ERROR_amp_N359501) >
+  0.5,V(ERROR_amp_VCLAMP),
+ 125n)   }
X_ERROR_amp_U5         SDWN_N ERROR_amp_N360937 INV_BASIC_GEN PARAMS: VDD=1
+  VSS=0 VTHRESH=500E-3
C_ERROR_amp_C3         ERROR_amp_N360815 ERROR_amp_INNER_REF  20p
V_ERROR_amp_V1         ERROR_amp_N359583 0 15m
R_ERROR_amp_R6         ERROR_amp_INNER_REF ERROR_amp_ISINK  743k
C_ERROR_amp_C6         0 ERROR_amp_N361129  1n
R_ERROR_amp_R11         ERROR_amp_INNER_REF 0  2.4G
X_ERROR_amp_S1    ERROR_amp_FBREF_SHORT 0 ERROR_amp_INNER_FB ERROR_amp_ISINK
+  ErrorAmp_ERROR_amp_S1
E_ERROR_amp_ABM10         ERROR_amp_INNER_REF_CLAMP 0 VALUE { MIN(V(VIN),5)
+  }
R_ERROR_amp_R15         ERROR_amp_N359595 ERROR_amp_N359551  1
R_ERROR_amp_R1         ERROR_amp_INNER_FB ERROR_amp_N360745  1.29MEG
R_ERROR_amp_R21         ERROR_amp_N361475 ERROR_amp_VCTRLM_NEW  1
V_ERROR_amp_V6         ERROR_amp_N359505 0 0.744
R_ERROR_amp_R17         0 SWBY4  476k
G_ERROR_amp_ABMII3         ERROR_amp_ISINK 0 VALUE { IF(V(MIN_TOFF_CL) >
+  0.5,125n,0)    }
X_ERROR_amp_U3         FB ERROR_amp_N360843 ERROR_amp_N360883 COMP_BASIC_GEN
+  PARAMS: VDD=1 VSS=0 VTHRESH=0.5
R_ERROR_amp_R22         VIN ERROR_amp_N393735  1
E_ERROR_amp_ABM7         ERROR_amp_N361475 0 VALUE { IF(V(ERROR_amp_N393735) >
+  4.2, (( 1.87525777E-02*V(VAVG)**4 - 2.20315321E-01*V(VAVG)**3 +
+  9.73431332E-01*V(VAVG)**2 - 1.85835591E-00*V(VAVG) +
+  2.38622011E-00)*V(IAVG)**6 + (-2.42326463E-01*V(VAVG)**4 +
+  2.88433195E-00*V(VAVG)**3 - 1.24787556E+01*V(VAVG)**2 + 2.24688188E+01*V(VAVG)
+  - 2.66302826E+01)*V(IAVG)**5 + ( 1.23832222E-00*V(VAVG)**4 -
+  1.49096354E+01*V(VAVG)**3 + 6.32648562E+01*V(VAVG)**2 - 1.07430368E+02*V(VAVG)
+  + 1.17442809E+02)*V(IAVG)**4 + (-3.15815548E-00*V(VAVG)**4 +
+  3.84343302E+01*V(VAVG)**3 - 1.59944993E+02*V(VAVG)**2 + 2.54791827E+02*V(VAVG)
+  - 2.56839905E+02)*V(IAVG)**3 +
+ ( 4.21141863E-00*V(VAVG)**4 - 5.18109401E+01*V(VAVG)**3 +
+  2.11099663E+02*V(VAVG)**2 - 3.11510517E+02*V(VAVG) +
+  2.87326481E+02)*V(IAVG)**2 + (-2.82214040E-00*V(VAVG)**4 +
+  3.51128583E+01*V(VAVG)**3 - 1.39863141E+02*V(VAVG)**2 + 1.88335884E+02*V(VAVG)
+  - 1.54282979E+02)*V(IAVG) + ( 8.55038148E-01*V(VAVG)**4 -
+  1.07290366E+01*V(VAVG)**3 + 4.18267263E+01*V(VAVG)**2 - 5.13102436E+01*V(VAVG)
+  + 3.74070366E+01)),
+ IF(V(ERROR_amp_N393735)>3.3,((-5.95742879E-01*V(VAVG)**2 +
+  2.15290779E-00*V(VAVG) - 1.23308259E-00)*V(IAVG)**6 + (
+  6.74408456E-00*V(VAVG)**2 - 2.45596253E+01*V(VAVG) +
+  1.46144202E+01)*V(IAVG)**5 + (-3.04809609E+01*V(VAVG)**2 +
+  1.11878716E+02*V(VAVG) - 6.91078921E+01)*V(IAVG)**4 + (
+  6.97314481E+01*V(VAVG)**2 - 2.57918605E+02*V(VAVG) +
+  1.64936127E+02)*V(IAVG)**3 +  (-8.38318504E+01*V(VAVG)**2 +
+  3.12116385E+02*V(VAVG) - 2.05301492E+02)*V(IAVG)**2 + (
+  4.91682419E+01*V(VAVG)**2 - 1.83863832E+02*V(VAVG) + 1.23111866E+02)*V(IAVG) +
+  (-1.18276918E+01*V(VAVG)**2 + 4.43711017E+01*V(VAVG) - 2.74731621E+01)),
+ (( 2.35063531E-03*V(VAVG) + 7.01241595E-02)*V(IAVG)**6 + (
+  1.26530954E-01*V(VAVG) - 1.11726427E-00)*V(IAVG)**5 + (-1.29454099E-00*V(VAVG)
+  + 6.56158165E-00)*V(IAVG)**4 +( 4.47455670E-00*V(VAVG) -
+  1.81521918E+01)*V(IAVG)**3 +(-7.00163936E-00*V(VAVG) +
+  2.50029059E+01)*V(IAVG)**2 + ( 5.49651495E-00*V(VAVG) -
+  1.69007772E+01)*V(IAVG) + (-2.38749773E-00*V(VAVG) + 7.56586665E-00)))) }
C_ERROR_amp_C7         0 ERROR_amp_VCLAMP  1n
E_ERROR_amp_ABM3         ERROR_amp_N360787 0 VALUE { IF(V(ERROR_amp_VCLAMP) >
+  125n, 125n,
+ IF (V(ERROR_amp_VCLAMP) <-125n,
+ -125n,V(ERROR_amp_VCLAMP)))  }
C_ERROR_amp_C12         0 ERROR_amp_N393735  1n
G_ERROR_amp_ABM3I1         0 ERROR_amp_INNER_REF VALUE { IF((V(SDWN_N) < 0.5) |
+
+ (V(MIN_TOFF_CL) > 0.5),0,
+ V(ERROR_amp_N361099))  }
R_ERROR_amp_R12         ERROR_amp_N360787 ERROR_amp_N361129  1
C_ERROR_amp_C11         0 ERROR_amp_VCTRLM_NEW  1n
C_ERROR_amp_C1         VOS ERROR_amp_INNER_FB  20p
G_ERROR_amp_ABM2I1         ERROR_amp_N359583 ERROR_amp_N360871 VALUE {
+  IF(V(SS_NODE)>0.5, 1.75u, V(ERROR_amp_VCTRLM_NEW)*1u)    }
X_ERROR_amp_U10         FB ERROR_amp_N359505 ERROR_amp_N359501 COMP_BASIC_GEN
+  PARAMS: VDD=1 VSS=0 VTHRESH=0.5
X_ERROR_amp_U2         ERROR_amp_INNER_REF ERROR_amp_INNER_FB ERROR_amp_N361065
+  COMP_BASIC_GEN PARAMS: VDD=1 VSS=0 VTHRESH=0.5
R_ERROR_amp_R7         0 ERROR_amp_N360815  2.85k
X_ERROR_amp_U8         PAUSE P100 ERROR_amp_N359525 OR2_BASIC_GEN PARAMS: VDD=1
+  VSS=0 VTHRESH=500E-3
X_ERROR_amp_U7         ERROR_amp_N359595 ERROR_amp_N361129 SS_NODE
+  ERROR_amp_N361099 MUX2_BASIC_GEN PARAMS: VDD=1 VSS=0 VTHRESH=0.5
R_ERROR_amp_R20         0 ERROR_amp_N361163  50
X_ERROR_amp_S2    HS_ON 0 ERROR_amp_N360871 ERROR_amp_N360815
+  ErrorAmp_ERROR_amp_S2
R_ERROR_amp_R8         SWBY4 ERROR_amp_N360745  793.4k
X_Caprio_U12         Caprio_N23722 ISENSE_LS Caprio_N14289 COMP_BASIC_GEN
+  PARAMS: VDD=1 VSS=0 VTHRESH=0.5
X_Caprio_U14         Caprio_N15145 DRVH_PRE CAPRIO N20512 SRLATCHRHP_BASIC_GEN
+  PARAMS: VDD=1 VSS=0 VTHRESH=0.5
X_Caprio_U19         Caprio_N16390 Caprio_N16592 PAUSE AND2_BASIC_GEN PARAMS:
+  VDD=1 VSS=0 VTHRESH=500E-3
X_Caprio_U17         Caprio_N16592 Caprio_N17195  d_d2 PARAMS:
V_Caprio_V1         Caprio_N23722 0 1.5m
C_Caprio_C4         0 Caprio_N16592  1n
X_Caprio_U18         DRVH_PRE DRVL_PRE Caprio_N17195 NOR2_BASIC_GEN PARAMS:
+  VDD=1 VSS=0 VTHRESH=500E-3
X_Caprio_U16         MODE_LOGIC Caprio_N16390 INV_BASIC_GEN PARAMS: VDD=1 VSS=0
+  VTHRESH=500E-3
R_Caprio_R3         Caprio_N17195 Caprio_N16592  1.44k
X_Caprio_U13         DRVL_PRE Caprio_N14289 Caprio_N15145 AND2_BASIC_GEN
+  PARAMS: VDD=1 VSS=0 VTHRESH=500E-3
X_Curr_Limit_S5    Curr_Limit_N16803351 0 Curr_Limit_N16803282 0
+  Current_Limit_Curr_Limit_S5
R_Curr_Limit_R12         Curr_Limit_RS_8_CYCLE Curr_Limit_N16807543  150
C_Curr_Limit_C6         0 Curr_Limit_N16807543  1n IC=0
C_Curr_Limit_C10         0 Curr_Limit_HSLIMIT_THRESH  1n
X_Curr_Limit_U625         CLIMIT_HS Curr_Limit_N16807543 Curr_Limit_N16803351
+  OR2_BASIC_GEN PARAMS: VDD=1 VSS=0 VTHRESH=500E-3
X_Curr_Limit_U619         Curr_Limit_N16803282 Curr_Limit_N16803299
+  Curr_Limit_N16803181 COMP_BASIC_GEN PARAMS: VDD=1 VSS=0 VTHRESH=0.5
X_Curr_Limit_D11         Curr_Limit_N16774792 Curr_Limit_N16774858  d_d2 PARAMS:
+
V_Curr_Limit_V9         Curr_Limit_N16803299 0 7.5
X_Curr_Limit_U3         ISENSE_HS Curr_Limit_HSLIMIT_THRESH
+  Curr_Limit_N16849423 COMP_BASIC_GEN PARAMS: VDD=1 VSS=0 VTHRESH=0.5
V_Curr_Limit_V5         Curr_Limit_N55010 0 4.6
X_Curr_Limit_S3    Curr_Limit_HICCUP_RESET 0 Curr_Limit_N16774792 0
+  Current_Limit_Curr_Limit_S3
X_Curr_Limit_U4         Curr_Limit_N16849423 DRVH_PRE Curr_Limit_N16849411
+  AND2_BASIC_GEN PARAMS: VDD=1 VSS=0 VTHRESH=500E-3
X_Curr_Limit_D13         Curr_Limit_N16803282 Curr_Limit_N16803326  d_d2 PARAMS:
+
G_Curr_Limit_ABMII1         0 Curr_Limit_N16774792 VALUE {
+  V(Curr_Limit_N16774898)    }
R_Curr_Limit_R3         HICCUP Curr_Limit_N16774450  1
C_Curr_Limit_C8         0 Curr_Limit_N16849417  1n
X_Curr_Limit_D14         Curr_Limit_RS_8_CYCLE Curr_Limit_N16807543 d_d2
+  PARAMS:
C_Curr_Limit_C4         0 HICCUP  1n
R_Curr_Limit_R9         Curr_Limit_N16849411 Curr_Limit_N16849417  25
C_Curr_Limit_C9         0 Curr_Limit_N16803282  20n IC=0
X_Curr_Limit_U12         Curr_Limit_N16849417 Curr_Limit_N16849411  d_d2 PARAMS:
C_Curr_Limit_C5         0 Curr_Limit_N16805640  10n IC=0
C_Curr_Limit_C3         0 Curr_Limit_N16774792  20n IC=0
R_Curr_Limit_R7         0 Curr_Limit_N16774934  1e8
X_Curr_Limit_U618         DRVH_PRE Curr_Limit_N16803342 Curr_Limit_N16803354
+  MONOPOS_PS PARAMS: PW=20n
X_Curr_Limit_U13         Curr_Limit_N16849417 CLIMIT_HS BUF_BASIC_GEN PARAMS:
+  VDD=1 VSS=0 VTHRESH=0.5
R_Curr_Limit_R5         Curr_Limit_RS_8_CYCLE Curr_Limit_N16803181  1
C_Curr_Limit_C7         0 Curr_Limit_RS_8_CYCLE  1n
X_Curr_Limit_U612         Curr_Limit_N16774792 Curr_Limit_N16774804
+  Curr_Limit_N16774450 COMP_BASIC_GEN PARAMS: VDD=1 VSS=0 VTHRESH=0.5
R_Curr_Limit_R11         0 Curr_Limit_N16803354  1e8
X_Curr_Limit_D12         Curr_Limit_N16805640 HICCUP  d_d2 PARAMS:
X_Curr_Limit_U613         MIN_TOFF_CL Curr_Limit_N16774898 Curr_Limit_N16774934
+  MONOPOS_PS PARAMS: PW=20n
V_Curr_Limit_V3         Curr_Limit_N16774858 0 33
E_Curr_Limit_ABM5         Curr_Limit_N549041 0 VALUE { IF(V(VOS) < 0.6, 4.6,
+ V(Curr_Limit_N55010))   }
V_Curr_Limit_V8         Curr_Limit_N16803326 0 10
V_Curr_Limit_V4         Curr_Limit_N16774804 0 31.5
G_Curr_Limit_ABMII2         0 Curr_Limit_N16803282 VALUE {
+  V(Curr_Limit_N16803342)    }
R_Curr_Limit_R8         HICCUP Curr_Limit_N16805640  9.504k
R_Curr_Limit_R10         Curr_Limit_N549041 Curr_Limit_HSLIMIT_THRESH  1
X_Curr_Limit_U622         Curr_Limit_RS_8_CYCLE Curr_Limit_N16805640
+  Curr_Limit_HICCUP_RESET OR2_BASIC_GEN PARAMS: VDD=1 VSS=0 VTHRESH=500E-3
X_U7         MIN_TOFF MIN_TOFF_N INV_BASIC_GEN PARAMS: VDD=1 VSS=0
+  VTHRESH=500E-3
E_ABM1         L_DERATED 0 VALUE { 374.173E-12*abs(V(IL))**3 -
+  7.570E-9*abs(V(IL))**2 + 2.870E-9*abs(V(IL)) + 482.795E-9    }
R_R17         IL IL1  {686/1}
C_C3         0 SS_TR  5.0n
X_SoftStart_U9         SDWN_N SoftStart_SDWN INV_BASIC_GEN PARAMS: VDD=1 VSS=0
+  VTHRESH=500E-3
E_SoftStart_E2         SoftStart_N263709 0 VIN 0 -1
X_SoftStart_S2    PG 0 SoftStart_N247140 0 SoftStart_SoftStart_S2
C_SoftStart_C8         SoftStart_N263709 SoftStart_N247140  1n
X_SoftStart_S1    SoftStart_N234157 0 SS_TR 0 SoftStart_SoftStart_S1
E_SoftStart_ABM2         SoftStart_N247429 0 VALUE { {(LIMIT(V(SS_TR), 0, 1.25)
+
+ )*0.64}   }
X_SoftStart_U10         SoftStart_SDWN HICCUP SoftStart_N234157 OR2_BASIC_GEN
+  PARAMS: VDD=1 VSS=0 VTHRESH=500E-3
C_SoftStart_C7         0 SS_TR  5p
R_SoftStart_R11         SoftStart_N247134 SoftStart_N247140  18
E_SoftStart_ABM1         SoftStart_N220347 0 VALUE { IF(V(SDWN_N) < 0.5,0,1)
+  }
R_SoftStart_R12         SoftStart_N247170 SoftStart_N247140  10
C_SoftStart_C5         0 INT_VREF  1n
C_SoftStart_C4         0 SoftStart_N220353  1n
X_SoftStart_U11         SoftStart_N247134 0 d_dideal PARAMS:
V_SoftStart_V1         SoftStart_N221204 0 4.8
G_SoftStart_ABMII1         SoftStart_N221204 SS_TR VALUE {
+  V(SoftStart_N220353)*7.5u    }
X_SoftStart_U12         0 SoftStart_N247170 d_dideal PARAMS:
R_SoftStart_R10         SoftStart_N255172 INT_VREF  1
X_SoftStart_U8         SS_TR SoftStart_N221204  d_d2 PARAMS:
E_SoftStart_E3         SoftStart_N255172 0 SoftStart_N247429 SoftStart_N248006
+  1
R_SoftStart_R9         SoftStart_N220353 SoftStart_N220347  1
E_SoftStart_ABM3         SoftStart_N248006 0 VALUE { V(SoftStart_N247140)    }
C_C6         0 IL1  1n
R_R16         GND 0  1m
X_U8         SDWN_N SDWN INV_BASIC_GEN PARAMS: VDD=1 VSS=0 VTHRESH=500E-3
R_PWR_G_R1         PWR_G_N14627 PWR_G_N00497  1.44k
C_PWR_G_C1         0 PWR_G_N00497  1n
X_PWR_G_U10         PWR_G_N00497 EN_LOGIC UVLO_OUT PWR_G_N225619
+  NAND3_BASIC_GEN PARAMS: VDD=1 VSS=0 VTHRESH=500E-3
R_PWR_G_R4         PWR_G_N2234591 PWR_G_N222445  1
E_PWR_G_ABM7         PWR_G_N222172 0 VALUE { (V(PWR_G_N221839)+
+ +V(PWR_G_N222445))   }
E_PWR_G_ABM4         PWR_G_N2234591 0 VALUE { MAX(V(INT_VREF)*0.95,0.76)    }
C_PWR_G_C6         0 PWR_G_N221839  1n
X_PWR_G_U7         PWR_G_N00497 PWR_G_N14627  d_d2 PARAMS:
C_PWR_G_C4         0 PWR_G_N222445  1n
X_PWR_G_U9         PWR_G_N00497 PWR_G_OUT2 BUF_BASIC_GEN PARAMS: VDD=1 VSS=0
+  VTHRESH=0.5
R_PWR_G_R3         PWR_G_N222172 PWR_G_N14135  1
X_PWR_G_S1    PWR_G_N225619 0 PG 0 PG_SGND_PWR_G_S1
E_PWR_G_ABM6         PWR_G_N2233831 0 VALUE { (V(INT_VREF)*-0.05*
+ +V(PWR_G_OUT2))   }
R_PWR_G_R6         PWR_G_N2233831 PWR_G_N221839  1
X_PWR_G_U5         FB PWR_G_N14135 PWR_G_N14627 COMP_BASIC_GEN PARAMS: VDD=1
+  VSS=0 VTHRESH=0.5
C_PWR_G_C3         0 PWR_G_N14135  1n
X_U3         MIN_TON MIN_TON_N INV_BASIC_GEN PARAMS: VDD=1 VSS=0 VTHRESH=500E-3
R_R12         PVIN VIN  1m
R_R4         0 EN  400k
R_R3         N351928 N351938  200k
.ENDS TPS82085_TRANS
*$
.subckt TPS62085_H1 1 2 3 4
H_H1         3 4 VH_H1 1
VH_H1         1 2 0V
.ends TPS62085_H1
*$
.subckt Driver_U13_H1 1 2 3 4
H_U13_H1         3 4 VH_U13_H1 1
VH_U13_H1         1 2 0V
.ends Driver_U13_H1
*$
.subckt Driver_U13_S9 1 2 3 4
S_U13_S9         3 4 1 2 _U13_S9
RS_U13_S9         1 2 1G
.MODEL         _U13_S9 VSWITCH Roff=1e6 Ron=1 Voff=0.2 Von=0.8
.ends Driver_U13_S9
*$
.subckt Driver_U13_S10 1 2 3 4
S_U13_S10         3 4 1 2 _U13_S10
RS_U13_S10         1 2 1G
.MODEL         _U13_S10 VSWITCH Roff=1e6 Ron=1 Voff=0.2 Von=0.8
.ends Driver_U13_S10
*$
.subckt Driver_U13_S3 1 2 3 4
S_U13_S3         3 4 1 2 _U13_S3
RS_U13_S3         1 2 1G
.MODEL         _U13_S3 VSWITCH Roff=10e6 Ron=50m Voff=0.2 Von=0.8
.ends Driver_U13_S3
*$
.subckt Driver_U13_S6 1 2 3 4
S_U13_S6         3 4 1 2 _U13_S6
RS_U13_S6         1 2 1G
.MODEL         _U13_S6 VSWITCH Roff=1e6 Ron=1 Voff=0.2 Von=0.8
.ends Driver_U13_S6
*$
.subckt Driver_U13_S2 1 2 3 4
S_U13_S2         3 4 1 2 _U13_S2
RS_U13_S2         1 2 1G
.MODEL         _U13_S2 VSWITCH Roff=1e6 Ron=1 Voff=0.2 Von=0.8
.ends Driver_U13_S2
*$
.subckt Driver_U13_H2 1 2 3 4
H_U13_H2         3 4 VH_U13_H2 1
VH_U13_H2         1 2 0V
.ends Driver_U13_H2
*$
.subckt Driver_U13_S7 1 2 3 4
S_U13_S7         3 4 1 2 _U13_S7
RS_U13_S7         1 2 1G
.MODEL         _U13_S7 VSWITCH Roff=1e6 Ron=1 Voff=0.2 Von=0.8
.ends Driver_U13_S7
*$
.subckt Driver_U13_S5 1 2 3 4
S_U13_S5         3 4 1 2 _U13_S5
RS_U13_S5         1 2 1G
.MODEL         _U13_S5 VSWITCH Roff=1e6 Ron=1 Voff=0.2 Von=0.8
.ends Driver_U13_S5
*$
.subckt Driver_U13_S4 1 2 3 4
S_U13_S4         3 4 1 2 _U13_S4
RS_U13_S4         1 2 1G
.MODEL         _U13_S4 VSWITCH Roff=10e6 Ron=4m Voff=0.2 Von=0.8
.ends Driver_U13_S4
*$
.subckt Driver_U13_S8 1 2 3 4
S_U13_S8         3 4 1 2 _U13_S8
RS_U13_S8         1 2 1G
.MODEL         _U13_S8 VSWITCH Roff=1e6 Ron=1 Voff=0.2 Von=0.8
.ends Driver_U13_S8
*$
.subckt TPS62085_S11 1 2 3 4
S_S11         3 4 1 2 _S11
RS_S11         1 2 1G
.MODEL         _S11 VSWITCH Roff=100e6 Ron=200 Voff=0.2 Von=0.8
.ends TPS62085_S11
*$
.subckt Minton_U2_S1 1 2 3 4
S_U2_S1         3 4 1 2 _U2_S1
RS_U2_S1         1 2 1G
.MODEL         _U2_S1 VSWITCH Roff=100e6 Ron=1 Voff=0.2 Von=0.8
.ends Minton_U2_S1
*$
.subckt Minton_U2_S3 1 2 3 4
S_U2_S3         3 4 1 2 _U2_S3
RS_U2_S3         1 2 1G
.model _U2_S3 VSWITCH (roff={max(630k,1)} ron={min(630k,1)} voff={if(630k>1,0.8,0.2)} von={if(630k>1,0.2,0.8)})
.ends Minton_U2_S3
*$
.subckt Minton_U2_S2 1 2 3 4
S_U2_S2         3 4 1 2 _U2_S2
RS_U2_S2         1 2 1G
.MODEL         _U2_S2 VSWITCH Roff=10e6 Ron=1.0 Voff=0.2 Von=0.8
.ends Minton_U2_S2
*$
.subckt LogicTrans_U4_S1 1 2 3 4
S_U4_S1         3 4 1 2 _U4_S1
RS_U4_S1         1 2 1G
.MODEL         _U4_S1 VSWITCH Roff=100e6 Ron=400k Voff=0.2 Von=0.8
.ends LogicTrans_U4_S1
*$
.subckt LogicTrans_U4_S3 1 2 3 4
S_U4_S3         3 4 1 2 _U4_S3
RS_U4_S3         1 2 1G
.MODEL         _U4_S3 VSWITCH Roff=100e6 Ron=400k Voff=0.2 Von=0.8
.ends LogicTrans_U4_S3
*$
.subckt Mintoff_Modified_Min_Toff_S2 1 2 3 4
S_Min_Toff_S2         3 4 1 2 _Min_Toff_S2
RS_Min_Toff_S2         1 2 1G
.MODEL         _Min_Toff_S2 VSWITCH Roff=10e6 Ron=1m Voff=0.2 Von=0.8
.ends Mintoff_Modified_Min_Toff_S2
*$
.subckt Mintoff_Modified_Min_Toff_S1 1 2 3 4
S_Min_Toff_S1         3 4 1 2 _Min_Toff_S1
RS_Min_Toff_S1         1 2 1G
.MODEL         _Min_Toff_S1 VSWITCH Roff=10e6 Ron=1.0 Voff=0.2 Von=0.8
.ends Mintoff_Modified_Min_Toff_S1
*$
.subckt ErrorAmp_ERROR_amp_S3 1 2 3 4
S_ERROR_amp_S3         3 4 1 2 _ERROR_amp_S3
RS_ERROR_amp_S3         1 2 1G
.model _ERROR_amp_S3 VSWITCH (roff={max(10G,10k)} ron={min(10G,10k)} voff={if(10G>10k,0.9V,0.2V)} von={if(10G>10k,0.2V,0.9V)})
.ends ErrorAmp_ERROR_amp_S3
*$
.subckt ErrorAmp_ERROR_amp_S1 1 2 3 4
S_ERROR_amp_S1         3 4 1 2 _ERROR_amp_S1
RS_ERROR_amp_S1         1 2 1G
.MODEL         _ERROR_amp_S1 VSWITCH Roff=1000e6 Ron=10k Voff=0.4V Von=0.8V
.ends ErrorAmp_ERROR_amp_S1
*$
.subckt ErrorAmp_ERROR_amp_S2 1 2 3 4
S_ERROR_amp_S2         3 4 1 2 _ERROR_amp_S2
RS_ERROR_amp_S2         1 2 1G
.MODEL         _ERROR_amp_S2 VSWITCH Roff=100e6 Ron=1m Voff=0.4V Von=0.8V
.ends ErrorAmp_ERROR_amp_S2
*$
.subckt Current_Limit_Curr_Limit_S5 1 2 3 4
S_Curr_Limit_S5         3 4 1 2 _Curr_Limit_S5
RS_Curr_Limit_S5         1 2 1G
.MODEL         _Curr_Limit_S5 VSWITCH Roff=1e6 Ron=1m Voff=0.25 Von=0.75
.ends Current_Limit_Curr_Limit_S5
*$
.subckt Current_Limit_Curr_Limit_S3 1 2 3 4
S_Curr_Limit_S3         3 4 1 2 _Curr_Limit_S3
RS_Curr_Limit_S3         1 2 1G
.MODEL         _Curr_Limit_S3 VSWITCH Roff=1e6 Ron=1m Voff=0.25 Von=0.75
.ends Current_Limit_Curr_Limit_S3
*$
.subckt SoftStart_SoftStart_S2 1 2 3 4
S_SoftStart_S2         3 4 1 2 _SoftStart_S2
RS_SoftStart_S2         1 2 1G
.MODEL         _SoftStart_S2 VSWITCH Roff=1e6 Ron=1m Voff=0.8V Von=.2V
.ends SoftStart_SoftStart_S2
*$
.subckt SoftStart_SoftStart_S1 1 2 3 4
S_SoftStart_S1         3 4 1 2 _SoftStart_S1
RS_SoftStart_S1         1 2 1G
.MODEL         _SoftStart_S1 VSWITCH Roff=1e9 Ron=100 Voff=0.2 Von=0.8
.ends SoftStart_SoftStart_S1
*$
.subckt PG_SGND_PWR_G_S1 1 2 3 4
S_PWR_G_S1         3 4 1 2 _PWR_G_S1
RS_PWR_G_S1         1 2 1G
.MODEL         _PWR_G_S1 VSWITCH Roff=30e6 Ron=150 Voff=0.2V Von=0.8
.ends PG_SGND_PWR_G_S1
*$
.subckt d_d2 1 2
d1 1 2 dd1
.model dd1 d
+ is=1e-010
+ rs=0.005
+ n=0.1
.ends d_d2
*$

.model D_D1 d
+ is=1e-010
+ rs=0.005
+ n=0.1
*$
.SUBCKT INV_BASIC_GEN A  Y PARAMS: VDD=1 VSS=0 VTHRESH=0.5
E_ABMGATE    YINT 0 VALUE {{IF(V(A) > {VTHRESH} ,
+ {VSS},{VDD})}}
RINT YINT Y 1
CINT Y 0 1n
.ENDS INV_BASIC_GEN
*$
.SUBCKT COMP_BASIC_GEN INP INM Y PARAMS: VDD=1 VSS=0 VTHRESH=0.5
E_ABM Yint 0 VALUE {IF (V(INP) >
+ V(INM), {VDD},{VSS})}
R1 Yint Y 1
C1 Y 0 1n
.ENDS COMP_BASIC_GEN
*$
.SUBCKT AND2_BASIC_GEN A B Y PARAMS: VDD=1 VSS=0 VTHRESH=0.5
E_ABMGATE    YINT 0 VALUE {{IF(V(A) > {VTHRESH}  &
+ V(B) > {VTHRESH},{VDD},{VSS})}}
RINT YINT Y 1
CINT Y 0 1n
.ENDS AND2_BASIC_GEN
*$
.SUBCKT OR2_BASIC_GEN A B Y PARAMS: VDD=1 VSS=0 VTHRESH=0.5
E_ABMGATE    YINT 0 VALUE {{IF(V(A) > {VTHRESH}  |
+ V(B) > {VTHRESH},{VDD},{VSS})}}
RINT YINT Y 1
CINT Y 0 1n
.ENDS OR2_BASIC_GEN
*$
.SUBCKT BUF_BASIC_GEN A  Y PARAMS: VDD=1 VSS=0 VTHRESH=0.5
E_ABMGATE    YINT 0 VALUE {{IF(V(A) > {VTHRESH} ,
+ {VDD},{VSS})}}
RINT YINT Y 1
CINT Y 0 1n
.ENDS BUF_BASIC_GEN
*$
.SUBCKT MONOPOS_PS in Q Qn PARAMS: PW=1u
VS VSUP 0 DC 1
GIN VSUP YA VALUE={IF(V(IN)>0.5, V(VSUP)/1000K, 0)}
GDIS YA 0 VALUE={IF(V(IN)>0.5,0, V(YA)/1m)}
CIN YA 0 1n IC=0
RIN YA 0 1e11
EABM1 YTD 0 VALUE={IF(V(YA)> {PW*1000}, 1, 0)}
RYTD YTD 0 1e11
EXOR P 0 VALUE={IF(V(YTD) > 0.5 != V(IN) > .5, 1, 0)}
ROUTpp2 P 0 1e11
EAND1 Q1 0 VALUE={ IF(V(P)>0.5 & V(IN)>0.5, 1, 0)}
Ro1 Q1 Q 1m
Co1 Q 0 1p
ROUT2 Q 0 1e11
EAND2 Qn1 0 VALUE={ IF(V(Q)>0.5, 0, 1)}
Ro2 Qn1 Qn 1m
Co2 Qn 0 1p
ROUT4 Qn 0 1e11
.ENDS MONOPOS_PS
*$
.SUBCKT AND3_BASIC_GEN A B C Y PARAMS: VDD=1 VSS=0 VTHRESH=0.5
E_ABMGATE    YINT 0 VALUE {{IF(V(A) > {VTHRESH}  &
+ V(B) > {VTHRESH} &
+ V(C) > {VTHRESH},{VDD},{VSS})}}
RINT YINT Y 1
CINT Y 0 1n
.ENDS AND3_BASIC_GEN
*$
.SUBCKT NOR2_BASIC_GEN A B Y PARAMS: VDD=1 VSS=0 VTHRESH=0.5
E_ABMGATE    YINT 0 VALUE {{IF(V(A) > {VTHRESH}  |
+ V(B) > {VTHRESH},{VSS},{VDD})}}
RINT YINT Y 1
CINT Y 0 1n
.ENDS NOR2_BASIC_GEN
*$
.SUBCKT AND4_BASIC_GEN A B C D Y PARAMS: VDD=1 VSS=0 VTHRESH=0.5
E_ABMGATE    YINT 0 VALUE {{IF(V(A) > {VTHRESH}  &
+ V(B) > {VTHRESH} &
+ V(C) > {VTHRESH} &
+ V(D) > {VTHRESH},{VDD},{VSS})}}
RINT YINT Y 1
CINT Y 0 1n
.ENDS AND4_BASIC_GEN
*$
.SUBCKT SRLATCHRHP_BASIC_GEN S R Q QB PARAMS: VDD=1 VSS=0 VTHRESH=0.5
GQ 0 Qint VALUE = {IF(V(R) > {VTHRESH},-5,IF(V(S)>{VTHRESH},5, 0))}
CQint Qint 0 1n
RQint Qint 0 1000MEG
D_D10 Qint MY5 D_D1
V1 MY5 0 {VDD}
D_D11 MYVSS Qint D_D1
V2 MYVSS 0 {VSS}
EQ Qqq 0 Qint 0 1
X3 Qqq Qqqd1 BUF_BASIC_GEN PARAMS: VDD={VDD} VSS={VSS} VTHRESH={VTHRESH}
RQq Qqqd1 Q 1
EQb Qbr 0 VALUE = {IF( V(Q) > {VTHRESH}, {VSS},{VDD})}
RQb Qbr QB 1
Cdummy1 Q 0 1n
Cdummy2 QB 0 1n
.IC V(Qint) {VSS}
.ENDS SRLATCHRHP_BASIC_GEN
*$
.SUBCKT BUF_DELAY_BASIC_GEN A  Y PARAMS: VDD=1 VSS=0 VTHRESH=0.5 DELAY = 10n
E_ABMGATE1    YINT1 0 VALUE {{IF(V(A) > {VTHRESH} ,
+ {VDD},{VSS})}}
RINT YINT1 YINT2 1
CINT YINT2 0 {DELAY*1.3}
E_ABMGATE2    YINT3 0 VALUE {{IF(V(YINT2) > {VTHRESH} ,
+ {VDD},{VSS})}}
RINT2 YINT3 Y 1
CINT2 Y 0 1n
.ENDS BUF_DELAY_BASIC_GEN
*$
.SUBCKT OR3_BASIC_GEN A B C Y PARAMS: VDD=1 VSS=0 VTHRESH=0.5
E_ABMGATE    YINT 0 VALUE {{IF(V(A) > {VTHRESH}  |
+ V(B) > {VTHRESH} |
+ V(C) > {VTHRESH},{VDD},{VSS})}}
RINT YINT Y 1
CINT Y 0 1n
.ENDS OR3_BASIC_GEN
*$
.SUBCKT MUX2_BASIC_GEN A B S Y PARAMS: VDD=1 VSS=0 VTHRESH=0.5
E_ABMGATE  YINT 0 VALUE {{IF(V(S) > {VTHRESH},
+ V(B),V(A))}}
RINT YINT Y 1
CINT Y 0 1n
.ENDS MUX2_BASIC_GEN
*$
.SUBCKT NAND3_BASIC_GEN A B C Y PARAMS: VDD=1 VSS=0 VTHRESH=0.5
E_ABMGATE    YINT 0 VALUE {{IF(V(A) > {VTHRESH}  &
+ V(B) > {VTHRESH} &
+ V(C) > {VTHRESH},{VSS},{VDD})}}
RINT YINT Y 1
CINT Y 0 1n
.ENDS NAND3_BASIC_GEN
*$
.SUBCKT INV_DELAY_BASIC_GEN A  Y PARAMS: VDD=1 VSS=0 VTHRESH=0.5 DELAY = 10n
E_ABMGATE1    YINT1 0 VALUE {{IF(V(A) > {VTHRESH} ,
+ {VDD},{VSS})}}
RINT YINT1 YINT2 1
CINT YINT2 0 {DELAY*1.3}
E_ABMGATE2    YINT3 0 VALUE {{IF(V(YINT2) > {VTHRESH} ,
+ {VSS},{VDD})}}
RINT2 YINT3 Y 1
CINT2 Y 0 1n
.ENDS INV_DELAY_BASIC_GEN
*$
.SUBCKT OR4_BASIC_GEN A B C D Y PARAMS: VDD=1 VSS=0 VTHRESH=0.5
E_ABMGATE    YINT 0 VALUE {{IF(V(A) > {VTHRESH}  |
+ V(B) > {VTHRESH} |
+ V(C) > {VTHRESH} |
+ V(D) > {VTHRESH},{VDD},{VSS})}}
RINT YINT Y 1
CINT Y 0 1n
.ENDS OR4_BASIC_GEN
*$
.SUBCKT VARIIND 1 2 CTRL
GC 1 2 Value={V(INT)/V(CTRL)}
GINT 0 INT Value={V(1,2)}
CINT INT 0 1
RINT INT 0 10Meg
.ENDS
*$
.subckt d_dideal 1 2
d1 1 2 dd1
.model dd1 d
+ is=1e-015
+ rs=0.01
+ n=0.001
.ends d_dideal
*$

.SUBCKT CESR 1 2 PARAMS: C=10u ESR=2m ESL=510p IC=0
C1 1 INT1 {C} IC={IC}
R1 INT1 INT2 {ESR}
L1 INT2 2 {ESL}
.ENDS CESR
*$

Xentry EN FB GND_0 GND_1 PG VIN_0 VIN_1 VOUT PAD TPS82085_TRANS
.ENDS library_simulation_spice_subcircuit_3
CCI0 N1 0 10U
CCO0 N4 0 22U
RRTOP0 N4 N2 110K
RRBOT0 N2 0 10K
RRFREQ N3 0 44.2K
CCI1 N4 0 10U
CCO1 N7 0 22U
RRTOP1 N7 N5 523K
RRBOT1 N5 0 100K
CCSS N6 0 10N
CCI2 N7 0 10U
CCO2 OUT12 0 22U
RRTOP2 OUT12 N8 100K
RRBOT2 N8 0 100K
CCI3 N7 0 10U
CCO3 OUT18 0 22U
RRTOP3 OUT18 N9 200K
RRBOT3 N9 0 100K
Vsimulation_voltage_source_0 N1 0 DC 24
Isimulation_current_source_0 OUT12 0 PULSE(0.5 1 0 1n 1n 0.0025 0.005)
Isimulation_current_source_1 OUT18 0 PULSE(0.75 1.5 0 1n 1n 0.0025 0.005)
Xsimulation_spice_subcircuit_0 0 N10 N11 N1 N2 0 0 0 0 N12 N3 N13 N14 N15 N1 N4 N4 N4 library_simulation_spice_subcircuit_0
Xsimulation_spice_subcircuit_1 N4 0 N5 0 N16 N6 N4 N7 N7 library_simulation_spice_subcircuit_1
Xsimulation_spice_subcircuit_2 N7 N8 0 0 N17 N7 N7 OUT12 0 library_simulation_spice_subcircuit_2
Xsimulation_spice_subcircuit_3 N7 N9 0 0 N18 N7 N7 OUT18 0 library_simulation_spice_subcircuit_3
* tscircuit_probe {"simulation_voltage_probe_id":"simulation_voltage_probe_0","name":"OUT12","spice_vector":"V(OUT12)","source_node_name":"OUT12"}
* tscircuit_probe {"simulation_voltage_probe_id":"simulation_voltage_probe_1","name":"OUT18","spice_vector":"V(OUT18)","source_node_name":"OUT18"}
.PRINT TRAN V(OUT12) V(OUT18)
.SAVE V(OUT12) V(OUT18)
.tran 1n 10u UIC
.END
